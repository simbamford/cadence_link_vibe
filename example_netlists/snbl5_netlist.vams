// AMS netlist generated by the AMS Unified netlister
// IC subversion:  IC23.1-64b.ISR2.29
// Xcelium version: 23.03-s007
// Copyright(C) 2005-2009, Cadence Design Systems, Inc
// User: sbamford Pid: 29880
// Design library name: enc_test
// Design cell name: snbl_5
// Design view name: config
// Solver: Spectre

`include "disciplines.vams"
`include "userDisciplines.vams"
// HDL file - enc_test, spike_source, functional.
// Library - cell_lib_std, Cell - NOR4_X1, View - schematic
// LAST TIME SAVED: Mar 15 13:48:34 2021
// NETLIST TIME: Sep 15 16:11:14 2025

`worklib cell_lib_std
`view schematic

`timescale 1ns / 1ps
(* cds_ams_schematic *)

module NOR4_X1 (y, a, b, c, d, vdd, vss);
output  y;
input  a, b, c, d, vdd, vss;
ne #(.w(4.2e-07), .l(2.1e-07), .as(2.016e-13), .ad(2.016e-13), .ps(1.8e-06), .pd(1.8e-06), .nrs(0.642857), .nrd(0.642857), .m((1)*(1)), .par1((1)*(1)), .xf_subext(0))
(* integer passed_mfactor = "m"; *)
 M5 (net64, net62, net67, vss);
ne #(.w(4.2e-07), .l(2.1e-07), .as(2.016e-13), .ad(2.016e-13), .ps(1.8e-06), .pd(1.8e-06), .nrs(0.642857), .nrd(0.642857), .m((1)*(1)), .par1((1)*(1)), .xf_subext(0))
(* integer passed_mfactor = "m"; *)
 M4 (net67, net1, vss, vss);
ne #(.w(8.9e-07), .l(2.1e-07), .as(4.272e-13), .ad(4.272e-13), .ps(2.74e-06), .pd(2.74e-06), .nrs(0.303371), .nrd(0.303371), .m((1)*(1)), .par1((1)*(1)), .xf_subext(0))
(* integer passed_mfactor = "m"; *)
 ne (y, net64, vss, vss);
ne #(.w(4.2e-07), .l(2.1e-07), .as(2.016e-13), .ad(2.016e-13), .ps(1.8e-06), .pd(1.8e-06), .nrs(0.642857), .nrd(0.642857), .m((1)*(1)), .par1((1)*(1)), .xf_subext(0))
(* integer passed_mfactor = "m"; *)
 M1 (net62, c, vss, vss);
ne #(.w(4.2e-07), .l(2.1e-07), .as(2.016e-13), .ad(2.016e-13), .ps(1.8e-06), .pd(1.8e-06), .nrs(0.642857), .nrd(0.642857), .m((1)*(1)), .par1((1)*(1)), .xf_subext(0))
(* integer passed_mfactor = "m"; *)
 M0 (net62, d, vss, vss);
ne #(.w(4.2e-07), .l(2.1e-07), .as(2.016e-13), .ad(2.016e-13), .ps(1.8e-06), .pd(1.8e-06), .nrs(0.642857), .nrd(0.642857), .m((1)*(1)), .par1((1)*(1)), .xf_subext(0))
(* integer passed_mfactor = "m"; *)
 MN1 (net1, b, vss, vss);
ne #(.w(4.2e-07), .l(2.1e-07), .as(2.016e-13), .ad(2.016e-13), .ps(1.8e-06), .pd(1.8e-06), .nrs(0.642857), .nrd(0.642857), .m((1)*(1)), .par1((1)*(1)), .xf_subext(0))
(* integer passed_mfactor = "m"; *)
 MN2 (net1, a, vss, vss);
pe #(.w(1.41e-06), .l(2.1e-07), .as(6.768e-13), .ad(6.768e-13), .ps(3.78e-06), .pd(3.78e-06), .nrs(0.191489), .nrd(0.191489), .m((1)*(1)), .par1((1)*(1)))
(* integer passed_mfactor = "m"; *)
 pe (y, net64, vdd, vdd);
pe #(.w(7.2e-07), .l(2.1e-07), .as(3.456e-13), .ad(3.456e-13), .ps(2.4e-06), .pd(2.4e-06), .nrs(0.375), .nrd(0.375), .m((1)*(1)), .par1((1)*(1)))
(* integer passed_mfactor = "m"; *)
 M7 (net64, net62, vdd, vdd);
pe #(.w(7.2e-07), .l(2.1e-07), .as(3.456e-13), .ad(3.456e-13), .ps(2.4e-06), .pd(2.4e-06), .nrs(0.375), .nrd(0.375), .m((1)*(1)), .par1((1)*(1)))
(* integer passed_mfactor = "m"; *)
 M6 (net64, net1, vdd, vdd);
pe #(.w(7.2e-07), .l(2.1e-07), .as(3.456e-13), .ad(3.456e-13), .ps(2.4e-06), .pd(2.4e-06), .nrs(0.375), .nrd(0.375), .m((1)*(1)), .par1((1)*(1)))
(* integer passed_mfactor = "m"; *)
 M3 (net66, c, vdd, vdd);
pe #(.w(7.2e-07), .l(2.1e-07), .as(3.456e-13), .ad(3.456e-13), .ps(2.4e-06), .pd(2.4e-06), .nrs(0.375), .nrd(0.375), .m((1)*(1)), .par1((1)*(1)))
(* integer passed_mfactor = "m"; *)
 M2 (net62, d, net66, vdd);
pe #(.w(7.2e-07), .l(2.1e-07), .as(3.456e-13), .ad(3.456e-13), .ps(2.4e-06), .pd(2.4e-06), .nrs(0.375), .nrd(0.375), .m((1)*(1)), .par1((1)*(1)))
(* integer passed_mfactor = "m"; *)
 MP2 (net65, b, vdd, vdd);
pe #(.w(7.2e-07), .l(2.1e-07), .as(3.456e-13), .ad(3.456e-13), .ps(2.4e-06), .pd(2.4e-06), .nrs(0.375), .nrd(0.375), .m((1)*(1)), .par1((1)*(1)))
(* integer passed_mfactor = "m"; *)
 MP1 (net1, a, net65, vdd);

endmodule
// Library - cell_lib_std, Cell - NAND2_X1, View - schematic
// LAST TIME SAVED: Feb 22 16:42:48 2021
// NETLIST TIME: Sep 15 16:11:14 2025

`worklib cell_lib_std
`view schematic

`timescale 1ns / 1ps
(* cds_ams_schematic *)

module NAND2_X1 (y, a, b, vdd, vss);
output  y;
input  a, b, vdd, vss;
ne #(.w(8.9e-07), .l(2.1e-07), .as(4.272e-13), .ad(4.272e-13), .ps(2.74e-06), .pd(2.74e-06), .nrs(0.303371), .nrd(0.303371), .m((1)*(1)), .par1((1)*(1)), .xf_subext(0))
(* integer passed_mfactor = "m"; *)
 MN1 (y, a, net18, vss);
ne #(.w(8.9e-07), .l(2.1e-07), .as(4.272e-13), .ad(4.272e-13), .ps(2.74e-06), .pd(2.74e-06), .nrs(0.303371), .nrd(0.303371), .m((1)*(1)), .par1((1)*(1)), .xf_subext(0))
(* integer passed_mfactor = "m"; *)
 MN2 (net18, b, vss, vss);
pe #(.w(1.01e-06), .l(2.1e-07), .as(4.848e-13), .ad(4.848e-13), .ps(2.98e-06), .pd(2.98e-06), .nrs(0.267327), .nrd(0.267327), .m((1)*(1)), .par1((1)*(1)))
(* integer passed_mfactor = "m"; *)
 MP1 (y, a, vdd, vdd);
pe #(.w(1.01e-06), .l(2.1e-07), .as(4.848e-13), .ad(4.848e-13), .ps(2.98e-06), .pd(2.98e-06), .nrs(0.267327), .nrd(0.267327), .m((1)*(1)), .par1((1)*(1)))
(* integer passed_mfactor = "m"; *)
 MP2 (y, b, vdd, vdd);

endmodule
// Library - cell_lib_std, Cell - NOR5_X1, View - schematic
// LAST TIME SAVED: May  9 14:54:18 2025
// NETLIST TIME: Sep 15 16:11:14 2025

`worklib cell_lib_std
`view schematic

`timescale 1ns / 1ps
(* cds_ams_schematic *)

module NOR5_X1 (Q, A, B, C, D, E, vdd, vss);
output  Q;
input  A, B, C, D, E, vdd, vss;
ne #(.w(9.3e-07), .l(2.1e-07), .as(4.464e-13), .ad(4.464e-13), .ps(2.82e-06), .pd(2.82e-06), .nrs(0.290323), .nrd(0.290323), .m((1)*(1)), .par1((1)*(1)), .xf_subext(0))
(* integer passed_mfactor = "m"; *)
 M10 (Q, nand2, vss, vss);
ne #(.w(4.2e-07), .l(2.1e-07), .as(2.016e-13), .ad(2.016e-13), .ps(1.8e-06), .pd(1.8e-06), .nrs(0.642857), .nrd(0.642857), .m((1)*(1)), .par1((1)*(1)), .xf_subext(0))
(* integer passed_mfactor = "m"; *)
 M9 (nand2, nor2, net5, vss);
ne #(.w(4.2e-07), .l(2.1e-07), .as(2.016e-13), .ad(2.016e-13), .ps(1.8e-06), .pd(1.8e-06), .nrs(0.642857), .nrd(0.642857), .m((1)*(1)), .par1((1)*(1)), .xf_subext(0))
(* integer passed_mfactor = "m"; *)
 MN2 (net5, nor3, vss, vss);
ne #(.w(4.2e-07), .l(2.1e-07), .as(2.016e-13), .ad(2.016e-13), .ps(1.8e-06), .pd(1.8e-06), .nrs(0.642857), .nrd(0.642857), .m((1)*(1)), .par1((1)*(1)), .xf_subext(0))
(* integer passed_mfactor = "m"; *)
 M1 (nor2, A, vss, vss);
ne #(.w(4.2e-07), .l(2.1e-07), .as(2.016e-13), .ad(2.016e-13), .ps(1.8e-06), .pd(1.8e-06), .nrs(0.642857), .nrd(0.642857), .m((1)*(1)), .par1((1)*(1)), .xf_subext(0))
(* integer passed_mfactor = "m"; *)
 M0 (nor2, B, vss, vss);
ne #(.w(4.2e-07), .l(2.1e-07), .as(2.016e-13), .ad(2.016e-13), .ps(1.8e-06), .pd(1.8e-06), .nrs(0.642857), .nrd(0.642857), .m((1)*(1)), .par1((1)*(1)), .xf_subext(0))
(* integer passed_mfactor = "m"; *)
 MN1 (nor3, C, vss, vss);
ne #(.w(4.2e-07), .l(2.1e-07), .as(2.016e-13), .ad(2.016e-13), .ps(1.8e-06), .pd(1.8e-06), .nrs(0.642857), .nrd(0.642857), .m((1)*(1)), .par1((1)*(1)), .xf_subext(0))
(* integer passed_mfactor = "m"; *)
 M3 (nor3, E, vss, vss);
ne #(.w(4.2e-07), .l(2.1e-07), .as(2.016e-13), .ad(2.016e-13), .ps(1.8e-06), .pd(1.8e-06), .nrs(0.642857), .nrd(0.642857), .m((1)*(1)), .par1((1)*(1)), .xf_subext(0))
(* integer passed_mfactor = "m"; *)
 M2 (nor3, D, vss, vss);
pe #(.w(1.47e-06), .l(2.1e-07), .as(7.056e-13), .ad(7.056e-13), .ps(3.9e-06), .pd(3.9e-06), .nrs(0.183673), .nrd(0.183673), .m((1)*(1)), .par1((1)*(1)))
(* integer passed_mfactor = "m"; *)
 M11 (Q, nand2, vdd, vdd);
pe #(.w(7.2e-07), .l(2.1e-07), .as(3.456e-13), .ad(3.456e-13), .ps(2.4e-06), .pd(2.4e-06), .nrs(0.375), .nrd(0.375), .m((1)*(1)), .par1((1)*(1)))
(* integer passed_mfactor = "m"; *)
 MP1 (nand2, nor2, vdd, vdd);
pe #(.w(7.2e-07), .l(2.1e-07), .as(3.456e-13), .ad(3.456e-13), .ps(2.4e-06), .pd(2.4e-06), .nrs(0.375), .nrd(0.375), .m((1)*(1)), .par1((1)*(1)))
(* integer passed_mfactor = "m"; *)
 MP2 (nand2, nor3, vdd, vdd);
pe #(.w(7.2e-07), .l(2.1e-07), .as(3.456e-13), .ad(3.456e-13), .ps(2.4e-06), .pd(2.4e-06), .nrs(0.375), .nrd(0.375), .m((1)*(1)), .par1((1)*(1)))
(* integer passed_mfactor = "m"; *)
 M4 (net1, E, vdd, vdd);
pe #(.w(7.2e-07), .l(2.1e-07), .as(3.456e-13), .ad(3.456e-13), .ps(2.4e-06), .pd(2.4e-06), .nrs(0.375), .nrd(0.375), .m((1)*(1)), .par1((1)*(1)))
(* integer passed_mfactor = "m"; *)
 M5 (net2, D, net1, vdd);
pe #(.w(7.2e-07), .l(2.1e-07), .as(3.456e-13), .ad(3.456e-13), .ps(2.4e-06), .pd(2.4e-06), .nrs(0.375), .nrd(0.375), .m((1)*(1)), .par1((1)*(1)))
(* integer passed_mfactor = "m"; *)
 M7 (nor2, A, net4, vdd);
pe #(.w(7.2e-07), .l(2.1e-07), .as(3.456e-13), .ad(3.456e-13), .ps(2.4e-06), .pd(2.4e-06), .nrs(0.375), .nrd(0.375), .m((1)*(1)), .par1((1)*(1)))
(* integer passed_mfactor = "m"; *)
 M6 (nor3, C, net2, vdd);
pe #(.w(7.2e-07), .l(2.1e-07), .as(3.456e-13), .ad(3.456e-13), .ps(2.4e-06), .pd(2.4e-06), .nrs(0.375), .nrd(0.375), .m((1)*(1)), .par1((1)*(1)))
(* integer passed_mfactor = "m"; *)
 M8 (net4, B, vdd, vdd);

endmodule
// Library - cell_lib_std, Cell - NAND3_X1, View - schematic
// LAST TIME SAVED: Mar 15 17:15:05 2021
// NETLIST TIME: Sep 15 16:11:14 2025

`worklib cell_lib_std
`view schematic

`timescale 1ns / 1ps
(* cds_ams_schematic *)

module NAND3_X1 (y, a, b, c, vdd, vss);
output  y;
input  a, b, c, vdd, vss;
ne #(.w(8.9e-07), .l(2.1e-07), .as(4.272e-13), .ad(4.272e-13), .ps(2.74e-06), .pd(2.74e-06), .nrs(0.303371), .nrd(0.303371), .m((1)*(1)), .par1((1)*(1)), .xf_subext(0))
(* integer passed_mfactor = "m"; *)
 MN1 (y, a, net60, vss);
ne #(.w(8.9e-07), .l(2.1e-07), .as(4.272e-13), .ad(4.272e-13), .ps(2.74e-06), .pd(2.74e-06), .nrs(0.303371), .nrd(0.303371), .m((1)*(1)), .par1((1)*(1)), .xf_subext(0))
(* integer passed_mfactor = "m"; *)
 MN2 (net60, b, net61, vss);
ne #(.w(8.9e-07), .l(2.1e-07), .as(4.272e-13), .ad(4.272e-13), .ps(2.74e-06), .pd(2.74e-06), .nrs(0.303371), .nrd(0.303371), .m((1)*(1)), .par1((1)*(1)), .xf_subext(0))
(* integer passed_mfactor = "m"; *)
 MN3 (net61, c, vss, vss);
pe #(.w(1.01e-06), .l(2.1e-07), .as(4.848e-13), .ad(4.848e-13), .ps(2.98e-06), .pd(2.98e-06), .nrs(0.267327), .nrd(0.267327), .m((1)*(1)), .par1((1)*(1)))
(* integer passed_mfactor = "m"; *)
 MP1 (y, a, vdd, vdd);
pe #(.w(1.01e-06), .l(2.1e-07), .as(4.848e-13), .ad(4.848e-13), .ps(2.98e-06), .pd(2.98e-06), .nrs(0.267327), .nrd(0.267327), .m((1)*(1)), .par1((1)*(1)))
(* integer passed_mfactor = "m"; *)
 MP3 (y, c, vdd, vdd);
pe #(.w(1.01e-06), .l(2.1e-07), .as(4.848e-13), .ad(4.848e-13), .ps(2.98e-06), .pd(2.98e-06), .nrs(0.267327), .nrd(0.267327), .m((1)*(1)), .par1((1)*(1)))
(* integer passed_mfactor = "m"; *)
 MP2 (y, b, vdd, vdd);

endmodule
// Library - cell_lib_std, Cell - MUX2_X1, View - schematic
// LAST TIME SAVED: Apr 11 16:40:18 2022
// NETLIST TIME: Sep 15 16:11:14 2025

`worklib cell_lib_std
`view schematic

`timescale 1ns / 1ps
(* cds_ams_schematic *)

module MUX2_X1 (y, a, b, s, vdd, vss);
output  y;
input  a, b, s, vdd, vss;
ne #(.w(8.8e-07), .l(2.1e-07), .as(4.224e-13), .ad(4.224e-13), .ps(2.72e-06), .pd(2.72e-06), .nrs(0.306818), .nrd(0.306818), .m((1)*(1)), .par1((1)*(1)), .xf_subext(0))
(* integer passed_mfactor = "m"; *)
 M4 (y, net25, vss, vss);
ne #(.w(5.9e-07), .l(2.1e-07), .as(2.832e-13), .ad(2.832e-13), .ps(2.14e-06), .pd(2.14e-06), .nrs(0.457627), .nrd(0.457627), .m((1)*(1)), .par1((1)*(1)), .xf_subext(0))
(* integer passed_mfactor = "m"; *)
 M7 (net25, s, net29, vss);
ne #(.w(5.9e-07), .l(2.1e-07), .as(2.832e-13), .ad(2.832e-13), .ps(2.14e-06), .pd(2.14e-06), .nrs(0.457627), .nrd(0.457627), .m((1)*(1)), .par1((1)*(1)), .xf_subext(0))
(* integer passed_mfactor = "m"; *)
 M6 (net29, b, vss, vss);
ne #(.w(4.2e-07), .l(2.1e-07), .as(2.016e-13), .ad(2.016e-13), .ps(1.8e-06), .pd(1.8e-06), .nrs(0.642857), .nrd(0.642857), .m((1)*(1)), .par1((1)*(1)), .xf_subext(0))
(* integer passed_mfactor = "m"; *)
 M11 (net26, s, vss, vss);
ne #(.w(5.9e-07), .l(2.1e-07), .as(2.832e-13), .ad(2.832e-13), .ps(2.14e-06), .pd(2.14e-06), .nrs(0.457627), .nrd(0.457627), .m((1)*(1)), .par1((1)*(1)), .xf_subext(0))
(* integer passed_mfactor = "m"; *)
 MN2 (net25, net26, net27, vss);
ne #(.w(5.9e-07), .l(2.1e-07), .as(2.832e-13), .ad(2.832e-13), .ps(2.14e-06), .pd(2.14e-06), .nrs(0.457627), .nrd(0.457627), .m((1)*(1)), .par1((1)*(1)), .xf_subext(0))
(* integer passed_mfactor = "m"; *)
 MN1 (net27, a, vss, vss);
pe #(.w(1.41e-06), .l(2.1e-07), .as(6.768e-13), .ad(6.768e-13), .ps(3.78e-06), .pd(3.78e-06), .nrs(0.191489), .nrd(0.191489), .m((1)*(1)), .par1((1)*(1)))
(* integer passed_mfactor = "m"; *)
 M5 (y, net25, vdd, vdd);
pe #(.w(8e-07), .l(2.1e-07), .as(3.84e-13), .ad(3.84e-13), .ps(2.56e-06), .pd(2.56e-06), .nrs(0.3375), .nrd(0.3375), .m((1)*(1)), .par1((1)*(1)))
(* integer passed_mfactor = "m"; *)
 M9 (net30, b, vdd, vdd);
pe #(.w(8e-07), .l(2.1e-07), .as(3.84e-13), .ad(3.84e-13), .ps(2.56e-06), .pd(2.56e-06), .nrs(0.3375), .nrd(0.3375), .m((1)*(1)), .par1((1)*(1)))
(* integer passed_mfactor = "m"; *)
 M8 (net25, net26, net30, vdd);
pe #(.w(6.3e-07), .l(2.1e-07), .as(3.024e-13), .ad(3.024e-13), .ps(2.22e-06), .pd(2.22e-06), .nrs(0.428571), .nrd(0.428571), .m((1)*(1)), .par1((1)*(1)))
(* integer passed_mfactor = "m"; *)
 M10 (net26, s, vdd, vdd);
pe #(.w(8e-07), .l(2.1e-07), .as(3.84e-13), .ad(3.84e-13), .ps(2.56e-06), .pd(2.56e-06), .nrs(0.3375), .nrd(0.3375), .m((1)*(1)), .par1((1)*(1)))
(* integer passed_mfactor = "m"; *)
 MP1 (net28, a, vdd, vdd);
pe #(.w(8e-07), .l(2.1e-07), .as(3.84e-13), .ad(3.84e-13), .ps(2.56e-06), .pd(2.56e-06), .nrs(0.3375), .nrd(0.3375), .m((1)*(1)), .par1((1)*(1)))
(* integer passed_mfactor = "m"; *)
 MP2 (net25, s, net28, vdd);

endmodule
// Library - cell_lib_std, Cell - OR4_X1, View - schematic
// LAST TIME SAVED: Mar 15 14:00:25 2021
// NETLIST TIME: Sep 15 16:11:14 2025

`worklib cell_lib_std
`view schematic

`timescale 1ns / 1ps
(* cds_ams_schematic *)

module OR4_X1 (y, a, b, c, d, vdd, vss);
output  y;
input  a, b, c, d, vdd, vss;
ne #(.w(8.9e-07), .l(2.1e-07), .as(4.272e-13), .ad(4.272e-13), .ps(2.74e-06), .pd(2.74e-06), .nrs(0.303371), .nrd(0.303371), .m((1)*(1)), .par1((1)*(1)), .xf_subext(0))
(* integer passed_mfactor = "m"; *)
 M5 (y, net53, net56, vss);
ne #(.w(4.2e-07), .l(2.1e-07), .as(2.016e-13), .ad(2.016e-13), .ps(1.8e-06), .pd(1.8e-06), .nrs(0.642857), .nrd(0.642857), .m((1)*(1)), .par1((1)*(1)), .xf_subext(0))
(* integer passed_mfactor = "m"; *)
 M1 (net53, c, vss, vss);
ne #(.w(4.2e-07), .l(2.1e-07), .as(2.016e-13), .ad(2.016e-13), .ps(1.8e-06), .pd(1.8e-06), .nrs(0.642857), .nrd(0.642857), .m((1)*(1)), .par1((1)*(1)), .xf_subext(0))
(* integer passed_mfactor = "m"; *)
 M0 (net53, d, vss, vss);
ne #(.w(8.9e-07), .l(2.1e-07), .as(4.272e-13), .ad(4.272e-13), .ps(2.74e-06), .pd(2.74e-06), .nrs(0.303371), .nrd(0.303371), .m((1)*(1)), .par1((1)*(1)), .xf_subext(0))
(* integer passed_mfactor = "m"; *)
 M4 (net56, net1, vss, vss);
ne #(.w(4.2e-07), .l(2.1e-07), .as(2.016e-13), .ad(2.016e-13), .ps(1.8e-06), .pd(1.8e-06), .nrs(0.642857), .nrd(0.642857), .m((1)*(1)), .par1((1)*(1)), .xf_subext(0))
(* integer passed_mfactor = "m"; *)
 MN1 (net1, b, vss, vss);
ne #(.w(4.2e-07), .l(2.1e-07), .as(2.016e-13), .ad(2.016e-13), .ps(1.8e-06), .pd(1.8e-06), .nrs(0.642857), .nrd(0.642857), .m((1)*(1)), .par1((1)*(1)), .xf_subext(0))
(* integer passed_mfactor = "m"; *)
 MN2 (net1, a, vss, vss);
pe #(.w(1.36e-06), .l(2.1e-07), .as(6.528e-13), .ad(6.528e-13), .ps(3.68e-06), .pd(3.68e-06), .nrs(0.198529), .nrd(0.198529), .m((1)*(1)), .par1((1)*(1)))
(* integer passed_mfactor = "m"; *)
 M7 (y, net53, vdd, vdd);
pe #(.w(1.36e-06), .l(2.1e-07), .as(6.528e-13), .ad(6.528e-13), .ps(3.68e-06), .pd(3.68e-06), .nrs(0.198529), .nrd(0.198529), .m((1)*(1)), .par1((1)*(1)))
(* integer passed_mfactor = "m"; *)
 M6 (y, net1, vdd, vdd);
pe #(.w(7.2e-07), .l(2.1e-07), .as(3.456e-13), .ad(3.456e-13), .ps(2.4e-06), .pd(2.4e-06), .nrs(0.375), .nrd(0.375), .m((1)*(1)), .par1((1)*(1)))
(* integer passed_mfactor = "m"; *)
 M3 (net55, c, vdd, vdd);
pe #(.w(7.2e-07), .l(2.1e-07), .as(3.456e-13), .ad(3.456e-13), .ps(2.4e-06), .pd(2.4e-06), .nrs(0.375), .nrd(0.375), .m((1)*(1)), .par1((1)*(1)))
(* integer passed_mfactor = "m"; *)
 M2 (net53, d, net55, vdd);
pe #(.w(7.2e-07), .l(2.1e-07), .as(3.456e-13), .ad(3.456e-13), .ps(2.4e-06), .pd(2.4e-06), .nrs(0.375), .nrd(0.375), .m((1)*(1)), .par1((1)*(1)))
(* integer passed_mfactor = "m"; *)
 MP2 (net54, b, vdd, vdd);
pe #(.w(7.2e-07), .l(2.1e-07), .as(3.456e-13), .ad(3.456e-13), .ps(2.4e-06), .pd(2.4e-06), .nrs(0.375), .nrd(0.375), .m((1)*(1)), .par1((1)*(1)))
(* integer passed_mfactor = "m"; *)
 MP1 (net1, a, net54, vdd);

endmodule
// Library - cell_lib_std, Cell - OR2_X1, View - schematic
// LAST TIME SAVED: Feb 22 18:22:50 2021
// NETLIST TIME: Sep 15 16:11:14 2025

`worklib cell_lib_std
`view schematic

`timescale 1ns / 1ps
(* cds_ams_schematic *)

module OR2_X1 (y, a, b, vdd, vss);
output  y;
input  a, b, vdd, vss;
ne #(.w(8.9e-07), .l(2.1e-07), .as(4.272e-13), .ad(4.272e-13), .ps(2.74e-06), .pd(2.74e-06), .nrs(0.303371), .nrd(0.303371), .m((1)*(1)), .par1((1)*(1)), .xf_subext(0))
(* integer passed_mfactor = "m"; *)
 M2 (y, net1, vss, vss);
ne #(.w(4.2e-07), .l(2.1e-07), .as(2.016e-13), .ad(2.016e-13), .ps(1.8e-06), .pd(1.8e-06), .nrs(0.642857), .nrd(0.642857), .m((1)*(1)), .par1((1)*(1)), .xf_subext(0))
(* integer passed_mfactor = "m"; *)
 M1 (net1, b, vss, vss);
ne #(.w(4.2e-07), .l(2.1e-07), .as(2.016e-13), .ad(2.016e-13), .ps(1.8e-06), .pd(1.8e-06), .nrs(0.642857), .nrd(0.642857), .m((1)*(1)), .par1((1)*(1)), .xf_subext(0))
(* integer passed_mfactor = "m"; *)
 M0 (net1, a, vss, vss);
pe #(.w(7.2e-07), .l(2.1e-07), .as(3.456e-13), .ad(3.456e-13), .ps(2.4e-06), .pd(2.4e-06), .nrs(0.375), .nrd(0.375), .m((1)*(1)), .par1((1)*(1)))
(* integer passed_mfactor = "m"; *)
 M5 (net2, b, vdd, vdd);
pe #(.w(1.41e-06), .l(2.1e-07), .as(6.768e-13), .ad(6.768e-13), .ps(3.78e-06), .pd(3.78e-06), .nrs(0.191489), .nrd(0.191489), .m((1)*(1)), .par1((1)*(1)))
(* integer passed_mfactor = "m"; *)
 M4 (y, net1, vdd, vdd);
pe #(.w(7.2e-07), .l(2.1e-07), .as(3.456e-13), .ad(3.456e-13), .ps(2.4e-06), .pd(2.4e-06), .nrs(0.375), .nrd(0.375), .m((1)*(1)), .par1((1)*(1)))
(* integer passed_mfactor = "m"; *)
 M3 (net1, a, net2, vdd);

endmodule
// Library - cell_lib_std, Cell - NOR2_X1, View - schematic
// LAST TIME SAVED: Feb 22 18:22:40 2021
// NETLIST TIME: Sep 15 16:11:14 2025

`worklib cell_lib_std
`view schematic

`timescale 1ns / 1ps
(* cds_ams_schematic *)

module NOR2_X1 (y, a, b, vdd, vss);
output  y;
input  a, b, vdd, vss;
ne #(.w(9e-07), .l(2.1e-07), .as(4.32e-13), .ad(4.32e-13), .ps(2.76e-06), .pd(2.76e-06), .nrs(0.3), .nrd(0.3), .m((1)*(1)), .par1((1)*(1)), .xf_subext(0))
(* integer passed_mfactor = "m"; *)
 M5 (y, a, vss, vss);
ne #(.w(9e-07), .l(2.1e-07), .as(4.32e-13), .ad(4.32e-13), .ps(2.76e-06), .pd(2.76e-06), .nrs(0.3), .nrd(0.3), .m((1)*(1)), .par1((1)*(1)), .xf_subext(0))
(* integer passed_mfactor = "m"; *)
 M4 (y, b, vss, vss);
pe #(.w(1.41e-06), .l(2.1e-07), .as(6.768e-13), .ad(6.768e-13), .ps(3.78e-06), .pd(3.78e-06), .nrs(0.191489), .nrd(0.191489), .m((1)*(1)), .par1((1)*(1)))
(* integer passed_mfactor = "m"; *)
 M3 (y, a, net1, vdd);
pe #(.w(1.41e-06), .l(2.1e-07), .as(6.768e-13), .ad(6.768e-13), .ps(3.78e-06), .pd(3.78e-06), .nrs(0.191489), .nrd(0.191489), .m((1)*(1)), .par1((1)*(1)))
(* integer passed_mfactor = "m"; *)
 M2 (net1, b, vdd, vdd);

endmodule
// Library - cell_lib_std, Cell - INV_X1, View - schematic
// LAST TIME SAVED: Feb 22 00:11:37 2021
// NETLIST TIME: Sep 15 16:11:14 2025

`worklib cell_lib_std
`view schematic

`timescale 1ns / 1ps
(* cds_ams_schematic *)

module INV_X1 (y, a, vdd, vss);
output  y;
input  a, vdd, vss;
ne #(.w(5.8e-07), .l(2.1e-07), .as(2.784e-13), .ad(2.784e-13), .ps(2.12e-06), .pd(2.12e-06), .nrs(0.465517), .nrd(0.465517), .m((1)*(1)), .par1((1)*(1)), .xf_subext(0))
(* integer passed_mfactor = "m"; *)
 M1 (y, a, vss, vss);
pe #(.w(1.41e-06), .l(2.1e-07), .as(6.768e-13), .ad(6.768e-13), .ps(3.78e-06), .pd(3.78e-06), .nrs(0.191489), .nrd(0.191489), .m((1)*(1)), .par1((1)*(1)))
(* integer passed_mfactor = "m"; *)
 M0 (y, a, vdd, vdd);

endmodule
// Library - cell_lib_async, Cell - PU_X5, View - schematic
// LAST TIME SAVED: Apr 13 15:21:49 2025
// NETLIST TIME: Sep 15 16:11:14 2025

`worklib cell_lib_async
`view schematic

`timescale 1ns / 1ps
(* cds_ams_schematic *)

module PU_X5 (d, s, b, g);
input  b, g;
inout  d, s;
pe #(.w(4.5e-06), .l(2.1e-07), .as(2.16e-12), .ad(2.16e-12), .ps(9.96e-06), .pd(9.96e-06), .nrs(0.06), .nrd(0.06), .m((1)*(1)), .par1((1)*(1)))
(* integer passed_mfactor = "m"; *)
 MP2 (d, g, s, b);

endmodule
// Library - cell_lib_async, Cell - PU_X4, View - schematic
// LAST TIME SAVED: Apr 13 15:22:01 2025
// NETLIST TIME: Sep 15 16:11:14 2025

`worklib cell_lib_async
`view schematic

`timescale 1ns / 1ps
(* cds_ams_schematic *)

module PU_X4 (d, s, b, g);
input  b, g;
inout  d, s;
pe #(.w(3.6e-06), .l(2.1e-07), .as(1.728e-12), .ad(1.728e-12), .ps(8.16e-06), .pd(8.16e-06), .nrs(0.075), .nrd(0.075), .m((1)*(1)), .par1((1)*(1)))
(* integer passed_mfactor = "m"; *)
 MP2 (d, g, s, b);

endmodule
// Library - cell_lib_async, Cell - KEEP, View - schematic
// LAST TIME SAVED: Apr 19 14:33:06 2022
// NETLIST TIME: Sep 15 16:11:14 2025

`worklib cell_lib_async
`view schematic

`timescale 1ns / 1ps
(* cds_ams_schematic *)

module KEEP (y, vdd, vss);
input  vdd, vss;
inout  y;
ne #(.w(2.9e-07), .l(6.3e-07), .as(1.392e-13), .ad(1.392e-13), .ps(1.54e-06), .pd(1.54e-06), .nrs(0.931034), .nrd(0.931034), .m((1)*(1)), .par1((1)*(1)), .xf_subext(0))
(* integer passed_mfactor = "m"; *)
 M5 (net5, vdd, vss, vss);
ne #(.w(2.9e-07), .l(2.1e-07), .as(1.392e-13), .ad(1.392e-13), .ps(1.54e-06), .pd(1.54e-06), .nrs(0.931034), .nrd(0.931034), .m((1)*(1)), .par1((1)*(1)), .xf_subext(0))
(* integer passed_mfactor = "m"; *)
 M1 (net1, y, vss, vss);
ne #(.w(2.9e-07), .l(2.1e-07), .as(1.392e-13), .ad(1.392e-13), .ps(1.54e-06), .pd(1.54e-06), .nrs(0.931034), .nrd(0.931034), .m((1)*(1)), .par1((1)*(1)), .xf_subext(0))
(* integer passed_mfactor = "m"; *)
 M2 (y, net1, net5, vss);
pe #(.w(4.5e-07), .l(6.3e-07), .as(2.16e-13), .ad(2.16e-13), .ps(1.86e-06), .pd(1.86e-06), .nrs(0.6), .nrd(0.6), .m((1)*(1)), .par1((1)*(1)))
(* integer passed_mfactor = "m"; *)
 M4 (net6, vss, vdd, vdd);
pe #(.w(4.5e-07), .l(2.1e-07), .as(2.16e-13), .ad(2.16e-13), .ps(1.86e-06), .pd(1.86e-06), .nrs(0.6), .nrd(0.6), .m((1)*(1)), .par1((1)*(1)))
(* integer passed_mfactor = "m"; *)
 M3 (y, net1, net6, vdd);
pe #(.w(4.5e-07), .l(2.1e-07), .as(2.16e-13), .ad(2.16e-13), .ps(1.86e-06), .pd(1.86e-06), .nrs(0.6), .nrd(0.6), .m((1)*(1)), .par1((1)*(1)))
(* integer passed_mfactor = "m"; *)
 M0 (net1, y, vdd, vdd);

endmodule
// Library - cell_lib_async, Cell - A_1C1P_X1, View - schematic
// LAST TIME SAVED: Feb 25 12:58:04 2025
// NETLIST TIME: Sep 15 16:11:14 2025

`worklib cell_lib_async
`view schematic

`timescale 1ns / 1ps
(* cds_ams_schematic *)

module A_1C1P_X1 (y, c1, p1, vdd, vss);
output  y;
input  c1, p1, vdd, vss;
KEEP I_keep_0 (.y( y ), .vdd( vdd ), .vss( vss ));
ne #(.w(5.8e-07), .l(2.1e-07), .as(2.784e-13), .ad(2.784e-13), .ps(2.12e-06), .pd(2.12e-06), .nrs(0.465517), .nrd(0.465517), .m((1)*(1)), .par1((1)*(1)), .xf_subext(0))
(* integer passed_mfactor = "m"; *)
 M3 (y, c1, vss, vss);
pe #(.w(1.8e-06), .l(2.1e-07), .as(8.64e-13), .ad(8.64e-13), .ps(4.56e-06), .pd(4.56e-06), .nrs(0.15), .nrd(0.15), .m((1)*(1)), .par1((1)*(1)))
(* integer passed_mfactor = "m"; *)
 M4 (net1, p1, vdd, vdd);
pe #(.w(9e-07), .l(2.1e-07), .as(4.32e-13), .ad(2.43e-13), .ps(2.76e-06), .pd(1.44e-06), .nrs(0.3), .nrd(0.3), .m((1)*(2)), .par1((1)*(2)))
(* integer passed_mfactor = "m"; *)
 M0 (y, c1, net1, vdd);

endmodule
// Library - cell_lib_async, Cell - ARB2, View - schematic
// LAST TIME SAVED: May 19 14:02:52 2025
// NETLIST TIME: Sep 15 16:11:14 2025

`worklib cell_lib_async
`view schematic

`timescale 1ns / 1ps
(* cds_ams_schematic *)

module ARB2 (y1, y2, a, b, vdd, vss);
output  y1, y2;
input  a, b, vdd, vss;
wire var1;
wire var2;
NAND2_X1 nand_b (.y( var2 ), .vss( vss ), .vdd( vdd ), .a( var1 ), .b( b ));
NAND2_X1 nand_a (.y( var1 ), .vss( vss ), .vdd( vdd ), .a( var2 ), .b( a ));
ne #(.w(9e-07), .l(2.1e-07), .as(4.32e-13), .ad(4.32e-13), .ps(2.76e-06), .pd(2.76e-06), .nrs(0.3), .nrd(0.3), .m((1)*(1)), .par1((1)*(1)), .xf_subext(0))
(* integer passed_mfactor = "m"; *)
 M7 (y2, var2, vss, vss);
ne #(.w(9e-07), .l(2.1e-07), .as(4.32e-13), .ad(4.32e-13), .ps(2.76e-06), .pd(2.76e-06), .nrs(0.3), .nrd(0.3), .m((1)*(1)), .par1((1)*(1)), .xf_subext(0))
(* integer passed_mfactor = "m"; *)
 M4 (y1, var1, vss, vss);
pe #(.w(1.41e-06), .l(2.1e-07), .as(6.768e-13), .ad(6.768e-13), .ps(3.78e-06), .pd(3.78e-06), .nrs(0.191489), .nrd(0.191489), .m((1)*(1)), .par1((1)*(1)))
(* integer passed_mfactor = "m"; *)
 M1 (y2, var2, var1, vdd);
pe #(.w(1.41e-06), .l(2.1e-07), .as(6.768e-13), .ad(6.768e-13), .ps(3.78e-06), .pd(3.78e-06), .nrs(0.191489), .nrd(0.191489), .m((1)*(1)), .par1((1)*(1)))
(* integer passed_mfactor = "m"; *)
 M3 (y1, var1, var2, vdd);

endmodule
// Library - cell_lib_async, Cell - ARB_LONG, View - schematic
// LAST TIME SAVED: Apr 11 12:43:11 2025
// NETLIST TIME: Sep 15 16:11:14 2025

`worklib cell_lib_async
`view schematic

`timescale 1ns / 1ps
(* cds_ams_schematic *)

module ARB_LONG (out_a, out_b, vdd, vss, in_a, in_b);
output  out_a, out_b;
input  in_a, in_b;
inout  vdd, vss;
wire net3;
wire net4;
wire net1;
wire net2;
INV_X1 inv_a (.vdd( vdd ), .y( net4 ), .vss( vss ), .a( net3 ));
INV_X1 inv_b (.vdd( vdd ), .y( net2 ), .vss( vss ), .a( net1 ));
A_1C1P_X1 celem_b (.y( out_b ), .vss( vss ), .vdd( vdd ), .c1( net2 ), .p1( net3 ));
A_1C1P_X1 celem_a (.y( out_a ), .vss( vss ), .vdd( vdd ), .c1( net4 ), .p1( net1 ));
ARB2 arb (.vss( vss ), .vdd( vdd ), .y1( net3 ), .y2( net1 ), .a( in_a ), .b( in_b ));

endmodule
// Library - cell_lib_async, Cell - PD_X4, View - schematic
// LAST TIME SAVED: Apr 13 15:23:33 2025
// NETLIST TIME: Sep 15 16:11:14 2025

`worklib cell_lib_async
`view schematic

`timescale 1ns / 1ps
(* cds_ams_schematic *)

module PD_X4 (d, s, b, g);
input  b, g;
inout  d, s;
ne #(.w(2.32e-06), .l(2.1e-07), .as(1.1136e-12), .ad(1.1136e-12), .ps(5.6e-06), .pd(5.6e-06), .nrs(0.116379), .nrd(0.116379), .m((1)*(1)), .par1((1)*(1)), .xf_subext(0))
(* integer passed_mfactor = "m"; *)
 MP2 (d, g, s, b);

endmodule
// Library - cell_lib_async, Cell - PU_X1, View - schematic
// LAST TIME SAVED: Apr 16 16:45:25 2025
// NETLIST TIME: Sep 15 16:11:14 2025

`worklib cell_lib_async
`view schematic

`timescale 1ns / 1ps
(* cds_ams_schematic *)

module PU_X1 (d, s, b, g);
input  b, g;
inout  d, s;
pe #(.w(9e-07), .l(2.1e-07), .as(4.32e-13), .ad(4.32e-13), .ps(2.76e-06), .pd(2.76e-06), .nrs(0.3), .nrd(0.3), .m((1)*(1)), .par1((1)*(1)))
(* integer passed_mfactor = "m"; *)
 MP2 (d, g, s, b);

endmodule
// Library - cell_lib_async, Cell - PU_X2, View - schematic
// LAST TIME SAVED: Apr 16 16:45:47 2025
// NETLIST TIME: Sep 15 16:11:14 2025

`worklib cell_lib_async
`view schematic

`timescale 1ns / 1ps
(* cds_ams_schematic *)

module PU_X2 (d, s, b, g);
input  b, g;
inout  d, s;
pe #(.w(1.8e-06), .l(2.1e-07), .as(8.64e-13), .ad(8.64e-13), .ps(4.56e-06), .pd(4.56e-06), .nrs(0.15), .nrd(0.15), .m((1)*(1)), .par1((1)*(1)))
(* integer passed_mfactor = "m"; *)
 MP2 (d, g, s, b);

endmodule
// Library - cell_lib_async, Cell - PD_X1, View - schematic
// LAST TIME SAVED: Apr 16 16:47:16 2025
// NETLIST TIME: Sep 15 16:11:14 2025

`worklib cell_lib_async
`view schematic

`timescale 1ns / 1ps
(* cds_ams_schematic *)

module PD_X1 (d, s, b, g);
input  b, g;
inout  d, s;
ne #(.w(5.8e-07), .l(2.1e-07), .as(2.784e-13), .ad(2.784e-13), .ps(2.12e-06), .pd(2.12e-06), .nrs(0.465517), .nrd(0.465517), .m((1)*(1)), .par1((1)*(1)), .xf_subext(0))
(* integer passed_mfactor = "m"; *)
 MP2 (d, g, s, b);

endmodule
// Library - cell_lib_async, Cell - PD_X2, View - schematic
// LAST TIME SAVED: Apr 13 15:20:29 2025
// NETLIST TIME: Sep 15 16:11:14 2025

`worklib cell_lib_async
`view schematic

`timescale 1ns / 1ps
(* cds_ams_schematic *)

module PD_X2 (d, s, b, g);
input  b, g;
inout  d, s;
ne #(.w(1.16e-06), .l(2.1e-07), .as(5.568e-13), .ad(5.568e-13), .ps(3.28e-06), .pd(3.28e-06), .nrs(0.232759), .nrd(0.232759), .m((1)*(1)), .par1((1)*(1)), .xf_subext(0))
(* integer passed_mfactor = "m"; *)
 MP2 (d, g, s, b);

endmodule
// Library - cell_lib_async, Cell - PU_X3, View - schematic
// LAST TIME SAVED: Apr 13 15:22:22 2025
// NETLIST TIME: Sep 15 16:11:14 2025

`worklib cell_lib_async
`view schematic

`timescale 1ns / 1ps
(* cds_ams_schematic *)

module PU_X3 (d, s, b, g);
input  b, g;
inout  d, s;
pe #(.w(2.7e-06), .l(2.1e-07), .as(1.296e-12), .ad(1.296e-12), .ps(6.36e-06), .pd(6.36e-06), .nrs(0.1), .nrd(0.1), .m((1)*(1)), .par1((1)*(1)))
(* integer passed_mfactor = "m"; *)
 MP2 (d, g, s, b);

endmodule
// Library - cell_lib_async, Cell - PD_X3, View - schematic
// LAST TIME SAVED: Apr 16 16:48:00 2025
// NETLIST TIME: Sep 15 16:11:14 2025

`worklib cell_lib_async
`view schematic

`timescale 1ns / 1ps
(* cds_ams_schematic *)

module PD_X3 (d, s, b, g);
input  b, g;
inout  d, s;
ne #(.w(1.74e-06), .l(2.1e-07), .as(8.352e-13), .ad(8.352e-13), .ps(4.44e-06), .pd(4.44e-06), .nrs(0.155172), .nrd(0.155172), .m((1)*(1)), .par1((1)*(1)), .xf_subext(0))
(* integer passed_mfactor = "m"; *)
 MP2 (d, g, s, b);

endmodule
// Library - cell_lib_async, Cell - KEEPB_X1, View - schematic
// LAST TIME SAVED: Mar 15 00:21:51 2021
// NETLIST TIME: Sep 15 16:11:14 2025

`worklib cell_lib_async
`view schematic

`timescale 1ns / 1ps
(* cds_ams_schematic *)

module KEEPB_X1 (y, a, vdd, vss);
output  y;
input  vdd, vss;
inout  a;
ne #(.w(2.9e-07), .l(6.3e-07), .as(1.392e-13), .ad(1.392e-13), .ps(1.54e-06), .pd(1.54e-06), .nrs(0.931034), .nrd(0.931034), .m((1)*(1)), .par1((1)*(1)), .xf_subext(0))
(* integer passed_mfactor = "m"; *)
 M5 (net5, vdd, vss, vss);
ne #(.w(5.8e-07), .l(2.1e-07), .as(2.784e-13), .ad(2.784e-13), .ps(2.12e-06), .pd(2.12e-06), .nrs(0.465517), .nrd(0.465517), .m((1)*(1)), .par1((1)*(1)), .xf_subext(0))
(* integer passed_mfactor = "m"; *)
 M1 (y, a, vss, vss);
ne #(.w(2.9e-07), .l(2.1e-07), .as(1.392e-13), .ad(1.392e-13), .ps(1.54e-06), .pd(1.54e-06), .nrs(0.931034), .nrd(0.931034), .m((1)*(1)), .par1((1)*(1)), .xf_subext(0))
(* integer passed_mfactor = "m"; *)
 M2 (a, y, net5, vss);
pe #(.w(4.5e-07), .l(6.3e-07), .as(2.16e-13), .ad(2.16e-13), .ps(1.86e-06), .pd(1.86e-06), .nrs(0.6), .nrd(0.6), .m((1)*(1)), .par1((1)*(1)))
(* integer passed_mfactor = "m"; *)
 M4 (net6, vss, vdd, vdd);
pe #(.w(4.5e-07), .l(2.1e-07), .as(2.16e-13), .ad(2.16e-13), .ps(1.86e-06), .pd(1.86e-06), .nrs(0.6), .nrd(0.6), .m((1)*(1)), .par1((1)*(1)))
(* integer passed_mfactor = "m"; *)
 M3 (a, y, net6, vdd);
pe #(.w(9e-07), .l(2.1e-07), .as(4.32e-13), .ad(4.32e-13), .ps(2.76e-06), .pd(2.76e-06), .nrs(0.3), .nrd(0.3), .m((1)*(1)), .par1((1)*(1)))
(* integer passed_mfactor = "m"; *)
 M0 (y, a, vdd, vdd);

endmodule
// Library - snbl, Cell - snbl_merge, View - schematic
// LAST TIME SAVED: Sep 15 14:42:55 2025
// NETLIST TIME: Sep 15 16:11:14 2025

`worklib snbl
`view schematic

`timescale 1ns / 1ps
(* cds_ams_schematic *)

module snbl_merge (de, le, r, _rst, d0, d1, gnd, l, re, rst, vddd);
output  de, le;
input  _rst, d0, d1, gnd, re, rst, vddd;
output [0:3] r;
input [0:3] l;
wire r0;
wire r3;
wire r1;
wire r2;
wire l0;
wire l2;
wire l3;
wire l1;
wire enfi;
wire ly;
wire net54;
wire ls;
wire net49;
wire lsa;
wire net42;
wire lv;
wire net38;
wire rv;
wire net53;
wire _end;
wire net33;
wire _rv;
wire net58;
wire _enf;
wire rvi;
wire _enl;
wire net12;
wire _lsa;
wire _enfii;
wire enf;
wire net15;
wire _lv;
wire lsi;
wire net45;
wire net17;
wire endi;
wire dva;
wire net51;
wire net47;
wire \end ;
wire net43;
wire net29;
wire enl;
wire net34;
wire _r2;
wire net3;
wire net35;
wire net31;
wire net27;
wire net23;
wire net1;
wire _r0;
wire r3pd5;
wire r3pd4;
wire r3pd3;
wire r3pd2;
wire r3pd1b;
wire _r3;
wire r3pd1;
wire net7;
wire net6;
wire net20;
wire net18;
wire net11;
wire _r1;
wire dv;
wire _ls;
wire enfii;
wire _enli;
wire _endi;
wire _enfi;
wire _rvi;
wire enli;
wire net60;
wire net72;
wire net68;
wire net13;
wire net37;
wire net8;
wire net25;
wire net4;
wire net48;
wire net22;
wire net46;
wire net40;
wire net2;
wire net36;
cds_alias #(1) cds_alias_inst1 ( r0 ,  r[0] );
cds_alias #(1) cds_alias_inst2 ( r3 ,  r[3] );
cds_alias #(1) cds_alias_inst3 ( r1 ,  r[1] );
cds_alias #(1) cds_alias_inst4 ( r2 ,  r[2] );
cds_alias #(1) cds_alias_inst5 ( l0 ,  l[0] );
cds_alias #(1) cds_alias_inst6 ( l2 ,  l[2] );
cds_alias #(1) cds_alias_inst7 ( l3 ,  l[3] );
cds_alias #(1) cds_alias_inst8 ( l1 ,  l[1] );
PU_X5 M11 (.b( vddd ), .s( net54 ), .g( ly ), .d( enfi ));
PU_X5 M10 (.b( vddd ), .s( net49 ), .g( ls ), .d( net54 ));
PU_X5 M9 (.b( vddd ), .s( net42 ), .g( lsa ), .d( net49 ));
PU_X5 M8 (.b( vddd ), .s( net38 ), .g( lv ), .d( net42 ));
PU_X5 M76 (.b( vddd ), .s( vddd ), .g( rv ), .d( net38 ));
PU_X4 M29 (.b( vddd ), .s( net33 ), .g( _end ), .d( net53 ));
PU_X4 M81 (.b( vddd ), .s( vddd ), .g( _rv ), .d( net33 ));
PU_X4 M82 (.b( vddd ), .s( net53 ), .g( _enf ), .d( net58 ));
PU_X4 M83 (.b( vddd ), .s( net58 ), .g( _enl ), .d( rvi ));
PD_X2 M24 (.g( _lsa ), .s( gnd ), .d( net12 ), .b( gnd ));
PD_X2 M17 (.g( enf ), .s( net12 ), .d( _enfii ), .b( gnd ));
PD_X2 M88 (.g( _lv ), .s( gnd ), .d( net15 ), .b( gnd ));
PD_X2 M89 (.g( _enf ), .s( net15 ), .d( lsi ), .b( gnd ));
OR4_X1 or_lv (.vss( gnd ), .vdd( vddd ), .y( lv ), .a( l[0] ), .b( l[1] ), .c( l[2] ), .d( l[3] ));
PD_X3 M27 (.g( rv ), .s( gnd ), .d( net45 ), .b( gnd ));
PD_X3 M26 (.g( enf ), .s( net45 ), .d( net17 ), .b( gnd ));
PD_X3 M25 (.g( dva ), .s( net17 ), .d( endi ), .b( gnd ));
PD_X6_reduced M55 (.g( re ), .s( gnd ), .d( net51 ), .b( gnd ));
PD_X6_reduced M54 (.g( \end  ), .s( net51 ), .d( net47 ), .b( gnd ));
PD_X6_reduced M53 (.g( enf ), .s( net47 ), .d( net43 ), .b( gnd ));
PD_X6_reduced M52 (.g( enl ), .s( net43 ), .d( net29 ), .b( gnd ));
PD_X6_reduced M51 (.g( dva ), .s( net29 ), .d( net34 ), .b( gnd ));
PD_X6_reduced M50 (.g( d0 ), .s( net34 ), .d( _r2 ), .b( gnd ));
PD_X6_reduced M49 (.g( ly ), .s( net29 ), .d( net3 ), .b( gnd ));
PD_X6_reduced M48 (.g( l[2] ), .s( net3 ), .d( _r2 ), .b( gnd ));
PD_X6_reduced M23 (.g( re ), .s( gnd ), .d( net35 ), .b( gnd ));
PD_X6_reduced M22 (.g( \end  ), .s( net35 ), .d( net31 ), .b( gnd ));
PD_X6_reduced M21 (.g( enf ), .s( net31 ), .d( net27 ), .b( gnd ));
PD_X6_reduced M20 (.g( enl ), .s( net27 ), .d( net23 ), .b( gnd ));
PD_X6_reduced M19 (.g( ly ), .s( net23 ), .d( net1 ), .b( gnd ));
PD_X6_reduced M18 (.g( l[0] ), .s( net1 ), .d( _r0 ), .b( gnd ));
PD_X6_reduced M68 (.g( re ), .s( gnd ), .d( r3pd5 ), .b( gnd ));
PD_X6_reduced M67 (.g( \end  ), .s( r3pd5 ), .d( r3pd4 ), .b( gnd ));
PD_X6_reduced M66 (.g( enf ), .s( r3pd4 ), .d( r3pd3 ), .b( gnd ));
PD_X6_reduced M65 (.g( enl ), .s( r3pd3 ), .d( r3pd2 ), .b( gnd ));
PD_X6_reduced M64 (.g( dva ), .s( r3pd2 ), .d( r3pd1b ), .b( gnd ));
PD_X6_reduced M63 (.g( d1 ), .s( r3pd1b ), .d( _r3 ), .b( gnd ));
PD_X6_reduced M62 (.g( ly ), .s( r3pd2 ), .d( r3pd1 ), .b( gnd ));
PD_X6_reduced M61 (.g( l[3] ), .s( r3pd1 ), .d( _r3 ), .b( gnd ));
PD_X6_reduced M39 (.g( re ), .s( gnd ), .d( net7 ), .b( gnd ));
PD_X6_reduced M38 (.g( \end  ), .s( net7 ), .d( net6 ), .b( gnd ));
PD_X6_reduced M37 (.g( enf ), .s( net6 ), .d( net20 ), .b( gnd ));
PD_X6_reduced M36 (.g( enl ), .s( net20 ), .d( net18 ), .b( gnd ));
PD_X6_reduced M35 (.g( ly ), .s( net18 ), .d( net11 ), .b( gnd ));
PD_X6_reduced M34 (.g( l[1] ), .s( net11 ), .d( _r1 ), .b( gnd ));
OR2_X1 or_dv (.b( d0 ), .y( dv ), .vss( gnd ), .vdd( vddd ), .a( d1 ));
NOR2_X1 nor_ly (.vss( gnd ), .vdd( vddd ), .b( _lsa ), .y( ly ), .a( _lv ));
INV_X1 inv_ls (.vdd( vddd ), .a( _ls ), .y( ls ), .vss( gnd ));
INV_X1 inv_end_3 (.vss( gnd ), .y( de ), .vdd( vddd ), .a( _end ));
INV_X1 inv_enf_2 (.vdd( vddd ), .a( enfii ), .y( _enf ), .vss( gnd ));
INV_X1 inv_enl_2 (.vdd( vddd ), .a( enl ), .y( _enl ), .vss( gnd ));
INV_X1 inv_enl_1 (.vdd( vddd ), .a( _enli ), .y( enl ), .vss( gnd ));
INV_X1 inv_end_2 (.vdd( vddd ), .a( \end  ), .y( _end ), .vss( gnd ));
INV_X1 inv_end_1 (.vdd( vddd ), .a( _endi ), .y( \end  ), .vss( gnd ));
INV_X1 inv_enf_1 (.vdd( vddd ), .a( _enfi ), .y( enf ), .vss( gnd ));
INV_X1 inv_rv (.vdd( vddd ), .a( _rvi ), .y( rv ), .vss( gnd ));
INV_X1 inv_lv (.vdd( vddd ), .a( lv ), .y( _lv ), .vss( gnd ));
INV_X1 inv_lsa (.vdd( vddd ), .a( lsa ), .y( _lsa ), .vss( gnd ));
KEEPB_X1 keep_ls (.y( _ls ), .a( lsi ), .vdd( vddd ), .vss( gnd ));
KEEPB_X1 keep_enf_2 (.y( enfii ), .a( _enfii ), .vdd( vddd ), .vss( gnd ));
KEEPB_X1 keep_enl (.y( _enli ), .a( enli ), .vdd( vddd ), .vss( gnd ));
KEEPB_X1 keep_end (.y( _endi ), .a( endi ), .vdd( vddd ), .vss( gnd ));
KEEPB_X1 keep_enf_1 (.y( _enfi ), .a( enfi ), .vdd( vddd ), .vss( gnd ));
KEEPB_X1 keep_r3 (.y( r[3] ), .a( _r3 ), .vdd( vddd ), .vss( gnd ));
KEEPB_X1 keep_r2 (.y( r[2] ), .a( _r2 ), .vdd( vddd ), .vss( gnd ));
KEEPB_X1 keep_r0 (.y( r[0] ), .a( _r0 ), .vdd( vddd ), .vss( gnd ));
KEEPB_X1 keep_r1 (.y( r[1] ), .a( _r1 ), .vdd( vddd ), .vss( gnd ));
KEEPB_X1 keep_rv (.y( _rvi ), .a( rvi ), .vdd( vddd ), .vss( gnd ));
NOR4_X1 nor_rv (.y( _rv ), .d( r[3] ), .c( r[2] ), .b( r[1] ), .a( r[0] ), .vdd( vddd ), .vss( gnd ));
ARB_LONG arb (.vss( gnd ), .in_a( ls ), .vdd( vddd ), .out_b( dva ), .in_b( dv ), .out_a( lsa ));
PD_X4 M13 (.g( l[3] ), .s( net60 ), .d( enfi ), .b( gnd ));
PD_X4 M12 (.g( l[2] ), .s( net60 ), .d( enfi ), .b( gnd ));
PD_X4 M16 (.g( rv ), .s( gnd ), .d( net72 ), .b( gnd ));
PD_X4 M15 (.g( \end  ), .s( net72 ), .d( net68 ), .b( gnd ));
PD_X4 M14 (.g( ly ), .s( net68 ), .d( net60 ), .b( gnd ));
PD_X4 M7 (.g( l[1] ), .s( net13 ), .d( enli ), .b( gnd ));
PD_X4 M6 (.g( l[0] ), .s( net13 ), .d( enli ), .b( gnd ));
PD_X4 M5 (.g( rv ), .s( gnd ), .d( net37 ), .b( gnd ));
PD_X4 M4 (.g( \end  ), .s( net37 ), .d( net8 ), .b( gnd ));
PD_X4 M74 (.g( ly ), .s( net8 ), .d( net13 ), .b( gnd ));
PU_X1 M45 (.b( vddd ), .s( vddd ), .g( _rst ), .d( _r2 ));
PU_X1 M28 (.g( _rst ), .s( vddd ), .d( _r0 ), .b( vddd ));
PU_X1 M90 (.b( vddd ), .s( vddd ), .g( _rst ), .d( le ));
PU_X1 M78 (.b( vddd ), .s( vddd ), .g( _rst ), .d( endi ));
PU_X1 M75 (.b( vddd ), .s( vddd ), .g( _rst ), .d( enfi ));
PU_X1 M77 (.b( vddd ), .s( vddd ), .g( enf ), .d( _enfii ));
PU_X1 M58 (.b( vddd ), .s( vddd ), .g( _rst ), .d( _r3 ));
PU_X1 M71 (.b( vddd ), .s( vddd ), .g( _rst ), .d( enli ));
PU_X1 M40 (.b( vddd ), .s( vddd ), .g( _rst ), .d( _r1 ));
PU_X2 M70 (.b( vddd ), .s( net25 ), .g( enl ), .d( _r3 ));
PU_X2 M69 (.b( vddd ), .s( vddd ), .g( re ), .d( net25 ));
PU_X2 M57 (.b( vddd ), .s( net4 ), .g( enl ), .d( _r2 ));
PU_X2 M56 (.b( vddd ), .s( vddd ), .g( re ), .d( net4 ));
PU_X2 M47 (.b( vddd ), .s( net4 ), .g( \end  ), .d( _r2 ));
PU_X2 M46 (.b( vddd ), .s( net4 ), .g( enf ), .d( _r2 ));
PU_X2 M33 (.b( vddd ), .s( vddd ), .g( re ), .d( net48 ));
PU_X2 M32 (.b( vddd ), .s( net48 ), .g( \end  ), .d( _r0 ));
PU_X2 M31 (.b( vddd ), .s( net48 ), .g( enf ), .d( _r0 ));
PU_X2 M30 (.b( vddd ), .s( net48 ), .g( enl ), .d( _r0 ));
PU_X2 M92 (.b( vddd ), .s( net22 ), .g( _enl ), .d( le ));
PU_X2 M91 (.b( vddd ), .s( vddd ), .g( _enf ), .d( net22 ));
PU_X2 M80 (.b( vddd ), .s( net46 ), .g( dva ), .d( endi ));
PU_X2 M79 (.b( vddd ), .s( vddd ), .g( rv ), .d( net46 ));
PU_X2 M60 (.b( vddd ), .s( net25 ), .g( \end  ), .d( _r3 ));
PU_X2 M59 (.b( vddd ), .s( net25 ), .g( enf ), .d( _r3 ));
PU_X2 M73 (.b( vddd ), .s( net40 ), .g( ly ), .d( enli ));
PU_X2 M72 (.b( vddd ), .s( vddd ), .g( rv ), .d( net40 ));
PU_X2 M44 (.b( vddd ), .s( vddd ), .g( re ), .d( net2 ));
PU_X2 M43 (.b( vddd ), .s( net2 ), .g( \end  ), .d( _r1 ));
PU_X2 M42 (.b( vddd ), .s( net2 ), .g( enf ), .d( _r1 ));
PU_X2 M41 (.b( vddd ), .s( net2 ), .g( enl ), .d( _r1 ));
PU_X2 M86 (.b( vddd ), .s( net36 ), .g( _lv ), .d( lsi ));
PU_X2 M85 (.b( vddd ), .s( vddd ), .g( rst ), .d( net36 ));
PD_X1 M1 (.g( _enl ), .s( gnd ), .d( le ), .b( gnd ));
PD_X1 M84 (.g( _rv ), .s( gnd ), .d( rvi ), .b( gnd ));
PD_X1 M87 (.g( rst ), .s( gnd ), .d( lsi ), .b( gnd ));
PD_X1 M0 (.g( _enf ), .s( gnd ), .d( le ), .b( gnd ));

endmodule
// Library - snbl, Cell - snbl_inc, View - schematic
// LAST TIME SAVED: May 16 15:10:03 2025
// NETLIST TIME: Sep 15 16:11:14 2025

`worklib snbl
`view schematic

`timescale 1ns / 1ps
(* cds_ams_schematic *)

module snbl_inc (dbg_snbl_inc_c0, dbg_snbl_inc_c1, dbg_snbl_inc_i0, dbg_snbl_inc_i2, dbg_snbl_inc_i3, le, r, _rst, gnd, l, re, rst, vddd);
output  dbg_snbl_inc_c0, dbg_snbl_inc_c1, dbg_snbl_inc_i0, dbg_snbl_inc_i2, dbg_snbl_inc_i3, le;
input  _rst, gnd, re, rst, vddd;
output [0:3] r;
input [0:3] l;
wire r0;
wire i4;
wire i1;
wire l3;
wire i5;
wire l0;
wire l2;
wire l1;
wire net16;
wire c0;
wire _i3;
wire net40;
wire _i1;
wire net3;
wire _i5;
wire net21;
wire _i4;
wire net12;
wire net5;
wire net17;
wire net24;
wire net18;
wire c1;
wire i0;
wire i2;
wire net32;
wire net2;
wire net29;
wire net35;
wire net31;
wire net47;
wire net19;
wire net20;
wire net25;
wire net43;
wire net8;
wire net26;
wire net27;
wire net1;
wire net38;
wire net44;
wire net33;
wire _i2;
wire net28;
wire net34;
wire _i0;
wire i3;
wire net4;
wire net13;
wire net14;
wire net10;
wire net48;
wire net65;
wire net46;
wire net64;
cds_alias #(1) cds_alias_inst9 ( r0 ,  r[0] );
cds_alias #(1) cds_alias_inst10 ( i4 ,  r[2] );
cds_alias #(1) cds_alias_inst11 ( i1 ,  r[1] );
cds_alias #(1) cds_alias_inst12 ( l3 ,  l[3] );
cds_alias #(1) cds_alias_inst13 ( i5 ,  r[3] );
cds_alias #(1) cds_alias_inst14 ( l0 ,  l[0] );
cds_alias #(1) cds_alias_inst15 ( l2 ,  l[2] );
cds_alias #(1) cds_alias_inst16 ( l1 ,  l[1] );
PU_X3 M96 (.b( vddd ), .s( vddd ), .g( re ), .d( net16 ));
PU_X3 M118 (.b( vddd ), .s( net40 ), .g( _i3 ), .d( c0 ));
PU_X3 M119 (.b( vddd ), .s( net40 ), .g( _i1 ), .d( c0 ));
PU_X3 M117 (.b( vddd ), .s( net3 ), .g( re ), .d( net40 ));
PU_X3 M115 (.b( vddd ), .s( vddd ), .g( rst ), .d( net3 ));
PU_X3 M110 (.b( vddd ), .s( net21 ), .g( l[3] ), .d( _i5 ));
PU_X3 M85 (.b( vddd ), .s( net12 ), .g( l[2] ), .d( _i4 ));
PU_X3 M83 (.b( vddd ), .s( net5 ), .g( c0 ), .d( net12 ));
PU_X3 M82 (.b( vddd ), .s( vddd ), .g( re ), .d( net5 ));
PU_X3 M99 (.b( vddd ), .s( net16 ), .g( c0 ), .d( net21 ));
PU_X4 M41 (.b( vddd ), .s( vddd ), .g( re ), .d( net17 ));
PU_X4 M44 (.b( vddd ), .s( net24 ), .g( l[0] ), .d( _i1 ));
PU_X4 M43 (.b( vddd ), .s( net18 ), .g( l[1] ), .d( net24 ));
PU_X4 M42 (.b( vddd ), .s( net17 ), .g( c1 ), .d( net18 ));
NOR5_X1 nor_le (.vdd( vddd ), .vss( gnd ), .E( r[3] ), .Q( le ), .D( r[2] ), .C( i2 ), .B( r[1] ), .A( i0 ));
PD_X4 M35 (.g( l[0] ), .s( net32 ), .d( _i1 ), .b( gnd ));
PD_X4 M112 (.g( c0 ), .s( net29 ), .d( net2 ), .b( gnd ));
PD_X4 M46 (.g( c0 ), .s( net31 ), .d( net35 ), .b( gnd ));
PD_X4 M50 (.g( re ), .s( net47 ), .d( net31 ), .b( gnd ));
PD_X4 M10 (.g( c0 ), .s( net20 ), .d( net19 ), .b( gnd ));
PD_X4 M11 (.g( re ), .s( net25 ), .d( net20 ), .b( gnd ));
PD_X4 M51 (.g( _rst ), .s( gnd ), .d( net47 ), .b( gnd ));
PD_X4 M80 (.g( _rst ), .s( gnd ), .d( net43 ), .b( gnd ));
PD_X4 M92 (.g( re ), .s( net26 ), .d( net8 ), .b( gnd ));
PD_X4 M12 (.g( _rst ), .s( gnd ), .d( net25 ), .b( gnd ));
PD_X4 M111 (.g( l[3] ), .s( net2 ), .d( _i5 ), .b( gnd ));
PD_X4 M114 (.g( _rst ), .s( gnd ), .d( net27 ), .b( gnd ));
PD_X4 M113 (.g( re ), .s( net27 ), .d( net29 ), .b( gnd ));
PD_X4 M94 (.g( _rst ), .s( gnd ), .d( net26 ), .b( gnd ));
PD_X4 M90 (.g( c0 ), .s( net8 ), .d( net1 ), .b( gnd ));
PD_X4 M73 (.g( l[2] ), .s( net38 ), .d( _i3 ), .b( gnd ));
PD_X4 M74 (.g( l[3] ), .s( net38 ), .d( _i3 ), .b( gnd ));
PD_X4 M76 (.g( c1 ), .s( net44 ), .d( net38 ), .b( gnd ));
PD_X4 M81 (.g( re ), .s( net43 ), .d( net44 ), .b( gnd ));
PD_X4 M64 (.g( _rst ), .s( gnd ), .d( net33 ), .b( gnd ));
PD_X4 M60 (.g( l[1] ), .s( net28 ), .d( _i2 ), .b( gnd ));
PD_X4 M61 (.g( c1 ), .s( net34 ), .d( net28 ), .b( gnd ));
PD_X4 M62 (.g( re ), .s( net33 ), .d( net34 ), .b( gnd ));
PD_X4 I18 (.b( gnd ), .d( _i0 ), .s( net19 ), .g( l[0] ));
PD_X4 M87 (.g( l[2] ), .s( net1 ), .d( _i4 ), .b( gnd ));
PD_X4 M37 (.g( c1 ), .s( net31 ), .d( net32 ), .b( gnd ));
PD_X4 M45 (.g( l[1] ), .s( net35 ), .d( _i1 ), .b( gnd ));
KEEPB_X1 I130 (.y( r[1] ), .a( _i1 ), .vdd( vddd ), .vss( gnd ));
KEEPB_X1 I131 (.y( i2 ), .a( _i2 ), .vdd( vddd ), .vss( gnd ));
KEEPB_X1 I132 (.y( i3 ), .a( _i3 ), .vdd( vddd ), .vss( gnd ));
KEEPB_X1 I135 (.y( r[3] ), .a( _i5 ), .vdd( vddd ), .vss( gnd ));
KEEPB_X1 keep_i0 (.y( i0 ), .a( _i0 ), .vdd( vddd ), .vss( gnd ));
KEEPB_X1 I133 (.y( r[2] ), .a( _i4 ), .vdd( vddd ), .vss( gnd ));
PD_X1 M121 (.g( rst ), .s( gnd ), .d( c0 ), .b( gnd ));
NAND3_X1 I108 (.y( r[0] ), .vss( gnd ), .vdd( vddd ), .c( _i3 ), .b( _i2 ), .a( _i0 ));
PU_X2 M126 (.b( vddd ), .s( vddd ), .g( re ), .d( net4 ));
PU_X2 M128 (.b( vddd ), .s( net4 ), .g( _i4 ), .d( c1 ));
PU_X2 M127 (.b( vddd ), .s( net4 ), .g( _i5 ), .d( c1 ));
PU_X2 M116 (.b( vddd ), .s( net3 ), .g( c1 ), .d( c0 ));
PU_X2 M71 (.b( vddd ), .s( vddd ), .g( re ), .d( net13 ));
PU_X2 M72 (.b( vddd ), .s( net13 ), .g( c1 ), .d( _i3 ));
PU_X2 M53 (.b( vddd ), .s( vddd ), .g( re ), .d( net14 ));
PU_X2 M59 (.b( vddd ), .s( net14 ), .g( l[1] ), .d( _i2 ));
PU_X2 M9 (.g( l[0] ), .s( net10 ), .d( _i0 ), .b( vddd ));
PU_X2 M13 (.b( vddd ), .s( vddd ), .g( re ), .d( net10 ));
PU_X1 M40 (.b( vddd ), .s( vddd ), .g( _rst ), .d( _i1 ));
PU_X1 M79 (.b( vddd ), .s( vddd ), .g( _rst ), .d( _i4 ));
PU_X1 M125 (.b( vddd ), .s( vddd ), .g( c0 ), .d( c1 ));
PU_X1 M14 (.b( vddd ), .s( vddd ), .g( _rst ), .d( _i0 ));
PU_X1 M95 (.b( vddd ), .s( vddd ), .g( _rst ), .d( _i5 ));
PU_X1 M65 (.b( vddd ), .s( vddd ), .g( _rst ), .d( _i3 ));
PU_X1 M52 (.b( vddd ), .s( vddd ), .g( _rst ), .d( _i2 ));
PD_X2 M130 (.g( re ), .s( gnd ), .d( net48 ), .b( gnd ));
PD_X2 M122 (.g( re ), .s( gnd ), .d( net65 ), .b( gnd ));
PD_X3 M131 (.g( _i5 ), .s( gnd ), .d( net46 ), .b( gnd ));
PD_X3 M129 (.g( c0 ), .s( net48 ), .d( c1 ), .b( gnd ));
PD_X3 M132 (.g( _i4 ), .s( net46 ), .d( net48 ), .b( gnd ));
PD_X3 M124 (.g( _i3 ), .s( gnd ), .d( net64 ), .b( gnd ));
PD_X3 M120 (.g( c1 ), .s( net65 ), .d( c0 ), .b( gnd ));
PD_X3 M123 (.g( _i1 ), .s( net64 ), .d( net65 ), .b( gnd ));
rename I1 (.src( c1 ), .dst( dbg_snbl_inc_c1 ));
rename I142 (.src( i0 ), .dst( dbg_snbl_inc_i0 ));
rename I140 (.src( i2 ), .dst( dbg_snbl_inc_i2 ));
rename I139 (.src( c0 ), .dst( dbg_snbl_inc_c0 ));
rename I141 (.src( i3 ), .dst( dbg_snbl_inc_i3 ));

endmodule
// Library - snbl, Cell - snbl_encoder, View - schematic
// LAST TIME SAVED: Sep 12 17:29:15 2025
// NETLIST TIME: Sep 15 16:11:14 2025

`worklib snbl
`view schematic

`timescale 1ns / 1ps
(* cds_ams_schematic *)

module snbl_encoder (le, r, te, gnd, vddd, _rst, enable, l, re, rst, t0, t1);
output  le, te;
input  _rst, enable, re, rst, t0, t1;
inout  gnd, vddd;
output [0:3] r;
input [0:3] l;
wire [0:3] int;
wire [0:3] rPre;
wire int_en;
wire le_pre;
wire net3;
wire net2;
wire net1;
wire net4;
wire net5;
snbl_merge merge (.rst( rst ), .d1( t1 ), .de( te ), ._rst( _rst ), .vddd( vddd ), .d0( t0 ), .gnd( gnd ), .r( rPre[0:3] ), .re( re ), .l( int[0:3] ), .le( int_en ));
snbl_inc inc (.dbg_snbl_inc_c0( net5 ), .dbg_snbl_inc_c1( net4 ), .dbg_snbl_inc_i0( net1 ), .dbg_snbl_inc_i2( net2 ), .dbg_snbl_inc_i3( net3 ), .rst( rst ), ._rst( _rst ), .gnd( gnd ), .vddd( vddd ), .r( int[0:3] ), .re( int_en ), .l( l[0:3] ), .le( le_pre ));
MUX2_X1 mux_r_0 (.vss( gnd ), .vdd( vddd ), .y( r[0] ), .a( l[0] ), .b( rPre[0] ), .s( enable ));
MUX2_X1 mux_r_1 (.vss( gnd ), .vdd( vddd ), .y( r[1] ), .a( l[1] ), .b( rPre[1] ), .s( enable ));
MUX2_X1 mux_r_2 (.vss( gnd ), .vdd( vddd ), .y( r[2] ), .a( l[2] ), .b( rPre[2] ), .s( enable ));
MUX2_X1 mux_r_3 (.vss( gnd ), .vdd( vddd ), .y( r[3] ), .a( l[3] ), .b( rPre[3] ), .s( enable ));
MUX2_X1 mux_le (.vss( gnd ), .vdd( vddd ), .y( le ), .a( re ), .b( le_pre ), .s( enable ));

endmodule
// Library - snbl, Cell - PD_X6_reduced, View - schematic
// LAST TIME SAVED: Sep 15 16:10:47 2025
// NETLIST TIME: Sep 15 16:11:14 2025

`worklib snbl
`view schematic

`timescale 1ns / 1ps
(* cds_ams_schematic *)

module PD_X6_reduced (d, s, b, g);
input  b, g;
inout  d, s;
ne #(.w(5.8e-07), .l(2.1e-07), .as(2.784e-13), .ad(2.784e-13), .ps(2.12e-06), .pd(2.12e-06), .nrs(0.465517), .nrd(0.465517), .m((1)*(1)), .par1((1)*(1)), .xf_subext(0))
(* integer passed_mfactor = "m"; *)
 MP2 (d, g, s, b);

endmodule
// Library - enc_test, Cell - snbl_5, View - schematic
// LAST TIME SAVED: Sep 15 14:46:01 2025
// NETLIST TIME: Sep 15 16:11:14 2025

`worklib enc_test
`view schematic

`timescale 1ns / 1ps
(* cds_ams_schematic *)

module snbl_5 ( );
wire [0:9] net17;
wire [4:0] req_s;
wire [4:0] en_s;
wire [5:0] en_s_lr;
wire [0:9] net3;
wire [15:0] d_s;
wire [3:0] out_s;
wire reset_B;
wire reset;
wire vdd;
wire vdd_ext;
snbl_encoder snbl_4 (.gnd(cds_globals.\gnd! ), .enable( vdd ), .vddd( vdd ), .rst( reset ), .re( en_s_lr[4] ), .r( d_s[15:12] ), ._rst( reset_B ), .l({cds_globals.\gnd! , cds_globals.\gnd! , cds_globals.\gnd! , cds_globals.\gnd! }), .t1( req_s[4] ), .t0(cds_globals.\gnd! ), .te( en_s[4] ), .le( en_s_lr[5] ));
snbl_encoder snbl_3 (.gnd(cds_globals.\gnd! ), .enable( vdd ), .vddd( vdd ), .rst( reset ), .re( en_s_lr[3] ), .r( d_s[11:8] ), ._rst( reset_B ), .l( d_s[15:12] ), .t1( req_s[3] ), .t0(cds_globals.\gnd! ), .te( en_s[3] ), .le( en_s_lr[4] ));
snbl_encoder snbl_2 (.gnd(cds_globals.\gnd! ), .enable( vdd ), .vddd( vdd ), .rst( reset ), .re( en_s_lr[2] ), .r( d_s[7:4] ), ._rst( reset_B ), .l( d_s[11:8] ), .t1( req_s[2] ), .t0(cds_globals.\gnd! ), .te( en_s[2] ), .le( en_s_lr[3] ));
snbl_encoder snbl_1 (.gnd(cds_globals.\gnd! ), .enable( vdd ), .vddd( vdd ), .rst( reset ), .re( en_s_lr[1] ), .r( d_s[3:0] ), ._rst( reset_B ), .l( d_s[7:4] ), .t1( req_s[1] ), .t0(cds_globals.\gnd! ), .te( en_s[1] ), .le( en_s_lr[2] ));
snbl_encoder snbl_0 (.gnd(cds_globals.\gnd! ), .enable( vdd ), .vddd( vdd ), .rst( reset ), .re( en_s_lr[0] ), .r( out_s[3:0] ), ._rst( reset_B ), .l( d_s[3:0] ), .t1( req_s[0] ), .t0(cds_globals.\gnd! ), .te( en_s[0] ), .le( en_s_lr[1] ));
NOR4_X1 I_nor4_0 (.y( en_s_lr[0] ), .d( out_s[0] ), .c( out_s[1] ), .b( out_s[2] ), .a( out_s[3] ), .vdd( vdd_ext ), .vss(cds_globals.\gnd! ));
spike_source #(.T_SPREAD_NS(25)) I13 (.en_s( en_s ), .req_p( net17 ), .req_s( req_s ), .ack_p( net3 ));
vsource #(.dc(1.8), .type("dc")) V3 (vdd_ext, cds_globals.\gnd! );
vsource #(.dc(1.8), .type("dc")) V0 (vdd, cds_globals.\gnd! );
vsource #(.type("pulse"), .val0(0), .val1(1.8), .period(10), .delay(1e-09), .rise(1e-09), .fall(1e-09), .width(10)) V1 (reset_B, cds_globals.\gnd! );
vsource #(.type("pulse"), .val0(1.8), .val1(0), .period(10), .delay(1e-09), .rise(1e-09), .fall(1e-09), .width(10)) V2 (reset, cds_globals.\gnd! );

endmodule
// Library - spikeulike, Cell - rename, View - schematic
// LAST TIME SAVED: May 15 14:14:52 2025
// NETLIST TIME: Sep 15 16:11:14 2025

`worklib spikeulike
`view schematic

`timescale 1ns / 1ps
(* cds_ams_schematic *)

module rename (dst, src);
inout  dst, src;
iprobe I0 (src, dst);

endmodule
`noworklib
`noview
