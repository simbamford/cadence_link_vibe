// AMS netlist generated by the AMS Unified netlister
// IC subversion:  IC23.1-64b.ISR2.29
// Xcelium version: 23.03-s007
// Copyright(C) 2005-2009, Cadence Design Systems, Inc
// User: sbamford Pid: 29880
// Design library name: enc_test
// Design cell name: paer_5_of_10
// Design view name: config
// Solver: Spectre

`include "disciplines.vams"
`include "userDisciplines.vams"
// HDL file - enc_test, spike_source, functional.
// HDL file - p_10_1_1_b, tmpl_0_0neurosynaptic__perifery_0_0arbiter__handshake, functional.
// HDL file - p_10_1_1_b, tmpl_0_0neurosynaptic__perifery_0_0arbtree_310_4, functional.
// HDL file - p_10_1_1_b, tmpl_0_0neurosynaptic__perifery_0_0sigbuf_34_4, functional.
// HDL file - p_10_1_1_b, tmpl_0_0neurosynaptic__perifery_0_0sigbuf__boolarray_310_74_4, functional.
// HDL file - p_10_1_1_b, tmpl_0_0neurosynaptic__perifery_0_0ortree_38_4, functional.
// HDL file - p_10_1_1_b, tmpl_0_0neurosynaptic__perifery_0_0dualrail__encoder_34_710_4, functional.
// HDL file - p_10_1_1_b, tmpl_0_0neurosynaptic__perifery_0_0ctree_34_4, functional.
// HDL file - p_10_1_1_b, tmpl_0_0neurosynaptic__perifery_0_0vtree_34_4, functional.
// HDL file - p_10_1_1_b, tmpl_0_0neurosynaptic__perifery_0_0sigbuf_38_4, functional.
// HDL file - p_10_1_1_b, tmpl_0_0neurosynaptic__perifery_0_0buffer_34_4, functional.
// HDL file - p_10_1_1_b, tmpl_0_0neurosynaptic__perifery_0_0encoder1d__simple_34_710_4, functional.
// HDL file - p_10_1_1_b, tmpl_0_0neurosynaptic__perifery_0_0sigbuf_31_4, functional.
// HDL file - p_10_1_1_b, tmpl_0_0neurosynaptic__perifery_0_0fifo_34_71_4, functional.
// HDL file - p_10_1_1_b, tmpl_0_0neurosynaptic__perifery_0_0delayprog_31_4, functional.
// HDL file - p_10_1_1_b, tmpl_0_0neurosynaptic__perifery_0_0qdi2bd_34_71_4, functional.
// HDL file - p_10_1_1_b, tmpl_0_0neurosynaptic__perifery_0_0encoder1d__bd_34_710_71_71_4, functional.
// HDL file - p_10_1_1_b, sadc__encoder, functional.
// Library - cell_lib_std, Cell - TIELO_X1, View - schematic
// LAST TIME SAVED: Nov 25 19:02:55 2021
// NETLIST TIME: Sep 11 09:37:24 2025

`worklib cell_lib_std
`view schematic

`timescale 1ns / 1ps
(* cds_ams_schematic *)

module TIELO_X1 (y, vdd, vss);
output  y;
inout  vdd, vss;
ne #(.w(1.02e-06), .l(1.9e-07), .as(4.896e-13), .ad(4.896e-13), .ps(3e-06), .pd(3e-06), .nrs(0.264706), .nrd(0.264706), .m((1)*(1)), .par1((1)*(1)), .xf_subext(0))
(* integer passed_mfactor = "m"; *)
 MN3 (y, net24, vss, vss);
ne #(.w(9.45e-07), .l(1.85e-07), .as(4.536e-13), .ad(4.536e-13), .ps(2.85e-06), .pd(2.85e-06), .nrs(0.285714), .nrd(0.285714), .m((1)*(1)), .par1((1)*(1)), .xf_subext(0))
(* integer passed_mfactor = "m"; *)
 MN2 (y, net24, vss, vss);
ne #(.w(8.9e-07), .l(1.8e-07), .as(4.272e-13), .ad(4.272e-13), .ps(2.74e-06), .pd(2.74e-06), .nrs(0.303371), .nrd(0.303371), .m((1)*(1)), .par1((1)*(1)), .xf_subext(0))
(* integer passed_mfactor = "m"; *)
 MN1 (net23, net24, vss, vss);
pe #(.w(8.9e-07), .l(1.8e-07), .as(4.272e-13), .ad(4.272e-13), .ps(2.74e-06), .pd(2.74e-06), .nrs(0.303371), .nrd(0.303371), .m((1)*(1)), .par1((1)*(1)))
(* integer passed_mfactor = "m"; *)
 MP1 (net24, net23, vdd, vdd);

endmodule
// Library - cell_lib_std, Cell - INV_X2, View - schematic
// LAST TIME SAVED: Feb 22 01:22:17 2021
// NETLIST TIME: Sep 11 09:37:24 2025

`worklib cell_lib_std
`view schematic

`timescale 1ns / 1ps
(* cds_ams_schematic *)

module INV_X2 (y, a, vdd, vss);
output  y;
input  a, vdd, vss;
ne #(.w(5.8e-07), .l(2.1e-07), .as(2.784e-13), .ad(1.566e-13), .ps(2.12e-06), .pd(1.12e-06), .nrs(0.465517), .nrd(0.465517), .m((1)*(2)), .par1((1)*(2)), .xf_subext(0))
(* integer passed_mfactor = "m"; *)
 M1 (y, a, vss, vss);
pe #(.w(1.41e-06), .l(2.1e-07), .as(6.768e-13), .ad(3.807e-13), .ps(3.78e-06), .pd(1.95e-06), .nrs(0.191489), .nrd(0.191489), .m((1)*(2)), .par1((1)*(2)))
(* integer passed_mfactor = "m"; *)
 M0 (y, a, vdd, vdd);

endmodule
// Library - cell_lib_std, Cell - BUF_X4, View - schematic
// LAST TIME SAVED: Feb 24 12:26:52 2021
// NETLIST TIME: Sep 11 09:37:24 2025

`worklib cell_lib_std
`view schematic

`timescale 1ns / 1ps
(* cds_ams_schematic *)

module BUF_X4 (y, a, vdd, vss);
output  y;
input  a, vdd, vss;
ne #(.w(8.9e-07), .l(2.1e-07), .as(4.272e-13), .ad(2.403e-13), .ps(2.74e-06), .pd(1.43e-06), .nrs(0.303371), .nrd(0.303371), .m((1)*(2)), .par1((1)*(2)), .xf_subext(0))
(* integer passed_mfactor = "m"; *)
 M0 (net1, a, vss, vss);
ne #(.w(8e-07), .l(2.1e-07), .as(2.72e-13), .ad(2.72e-13), .ps(1.74667e-06), .pd(1.74667e-06), .nrs(0.3375), .nrd(0.3375), .m((1)*(3)), .par1((1)*(3)), .xf_subext(0))
(* integer passed_mfactor = "m"; *)
 ne (y, net1, vss, vss);
pe #(.w(1.445e-06), .l(2.1e-07), .as(6.936e-13), .ad(3.9015e-13), .ps(3.85e-06), .pd(1.985e-06), .nrs(0.186851), .nrd(0.186851), .m((1)*(2)), .par1((1)*(2)))
(* integer passed_mfactor = "m"; *)
 M1 (net1, a, vdd, vdd);
pe #(.w(1.47e-06), .l(2.1e-07), .as(5.5125e-13), .ad(3.969e-13), .ps(2.955e-06), .pd(2.01e-06), .nrs(0.183673), .nrd(0.183673), .m((1)*(4)), .par1((1)*(4)))
(* integer passed_mfactor = "m"; *)
 pe (y, net1, vdd, vdd);

endmodule
// Library - cell_lib_std, Cell - OR2_X1, View - schematic
// LAST TIME SAVED: Feb 22 18:22:50 2021
// NETLIST TIME: Sep 11 09:37:24 2025

`worklib cell_lib_std
`view schematic

`timescale 1ns / 1ps
(* cds_ams_schematic *)

module OR2_X1 (y, a, b, vdd, vss);
output  y;
input  a, b, vdd, vss;
ne #(.w(8.9e-07), .l(2.1e-07), .as(4.272e-13), .ad(4.272e-13), .ps(2.74e-06), .pd(2.74e-06), .nrs(0.303371), .nrd(0.303371), .m((1)*(1)), .par1((1)*(1)), .xf_subext(0))
(* integer passed_mfactor = "m"; *)
 M2 (y, net1, vss, vss);
ne #(.w(4.2e-07), .l(2.1e-07), .as(2.016e-13), .ad(2.016e-13), .ps(1.8e-06), .pd(1.8e-06), .nrs(0.642857), .nrd(0.642857), .m((1)*(1)), .par1((1)*(1)), .xf_subext(0))
(* integer passed_mfactor = "m"; *)
 M1 (net1, b, vss, vss);
ne #(.w(4.2e-07), .l(2.1e-07), .as(2.016e-13), .ad(2.016e-13), .ps(1.8e-06), .pd(1.8e-06), .nrs(0.642857), .nrd(0.642857), .m((1)*(1)), .par1((1)*(1)), .xf_subext(0))
(* integer passed_mfactor = "m"; *)
 M0 (net1, a, vss, vss);
pe #(.w(7.2e-07), .l(2.1e-07), .as(3.456e-13), .ad(3.456e-13), .ps(2.4e-06), .pd(2.4e-06), .nrs(0.375), .nrd(0.375), .m((1)*(1)), .par1((1)*(1)))
(* integer passed_mfactor = "m"; *)
 M5 (net2, b, vdd, vdd);
pe #(.w(1.41e-06), .l(2.1e-07), .as(6.768e-13), .ad(6.768e-13), .ps(3.78e-06), .pd(3.78e-06), .nrs(0.191489), .nrd(0.191489), .m((1)*(1)), .par1((1)*(1)))
(* integer passed_mfactor = "m"; *)
 M4 (y, net1, vdd, vdd);
pe #(.w(7.2e-07), .l(2.1e-07), .as(3.456e-13), .ad(3.456e-13), .ps(2.4e-06), .pd(2.4e-06), .nrs(0.375), .nrd(0.375), .m((1)*(1)), .par1((1)*(1)))
(* integer passed_mfactor = "m"; *)
 M3 (net1, a, net2, vdd);

endmodule
// Library - cell_lib_std, Cell - INV_X1, View - schematic
// LAST TIME SAVED: Feb 22 00:11:37 2021
// NETLIST TIME: Sep 11 09:37:24 2025

`worklib cell_lib_std
`view schematic

`timescale 1ns / 1ps
(* cds_ams_schematic *)

module INV_X1 (y, a, vdd, vss);
output  y;
input  a, vdd, vss;
ne #(.w(5.8e-07), .l(2.1e-07), .as(2.784e-13), .ad(2.784e-13), .ps(2.12e-06), .pd(2.12e-06), .nrs(0.465517), .nrd(0.465517), .m((1)*(1)), .par1((1)*(1)), .xf_subext(0))
(* integer passed_mfactor = "m"; *)
 M1 (y, a, vss, vss);
pe #(.w(1.41e-06), .l(2.1e-07), .as(6.768e-13), .ad(6.768e-13), .ps(3.78e-06), .pd(3.78e-06), .nrs(0.191489), .nrd(0.191489), .m((1)*(1)), .par1((1)*(1)))
(* integer passed_mfactor = "m"; *)
 M0 (y, a, vdd, vdd);

endmodule
// Library - cell_lib_std, Cell - BUF_X3, View - schematic
// LAST TIME SAVED: Feb 24 12:20:31 2021
// NETLIST TIME: Sep 11 09:37:24 2025

`worklib cell_lib_std
`view schematic

`timescale 1ns / 1ps
(* cds_ams_schematic *)

module BUF_X3 (y, a, vdd, vss);
output  y;
input  a, vdd, vss;
ne #(.w(6.3e-07), .l(2.1e-07), .as(3.024e-13), .ad(1.701e-13), .ps(2.22e-06), .pd(1.17e-06), .nrs(0.428571), .nrd(0.428571), .m((1)*(2)), .par1((1)*(2)), .xf_subext(0))
(* integer passed_mfactor = "m"; *)
 M0 (net1, a, vss, vss);
ne #(.w(8.9e-07), .l(2.1e-07), .as(4.272e-13), .ad(2.403e-13), .ps(2.74e-06), .pd(1.43e-06), .nrs(0.303371), .nrd(0.303371), .m((1)*(2)), .par1((1)*(2)), .xf_subext(0))
(* integer passed_mfactor = "m"; *)
 ne (y, net1, vss, vss);
pe #(.w(1.12e-06), .l(2.1e-07), .as(5.376e-13), .ad(3.024e-13), .ps(3.2e-06), .pd(1.66e-06), .nrs(0.241071), .nrd(0.241071), .m((1)*(2)), .par1((1)*(2)))
(* integer passed_mfactor = "m"; *)
 M1 (net1, a, vdd, vdd);
pe #(.w(1.47e-06), .l(2.1e-07), .as(4.998e-13), .ad(4.998e-13), .ps(2.64e-06), .pd(2.64e-06), .nrs(0.183673), .nrd(0.183673), .m((1)*(3)), .par1((1)*(3)))
(* integer passed_mfactor = "m"; *)
 pe (y, net1, vdd, vdd);

endmodule
// Library - cell_lib_std, Cell - AND2_X1, View - schematic
// LAST TIME SAVED: Feb 22 17:44:06 2021
// NETLIST TIME: Sep 11 09:37:24 2025

`worklib cell_lib_std
`view schematic

`timescale 1ns / 1ps
(* cds_ams_schematic *)

module AND2_X1 (y, a, b, vdd, vss);
output  y;
input  a, b, vdd, vss;
ne #(.w(8.9e-07), .l(2.1e-07), .as(4.272e-13), .ad(4.272e-13), .ps(2.74e-06), .pd(2.74e-06), .nrs(0.303371), .nrd(0.303371), .m((1)*(1)), .par1((1)*(1)), .xf_subext(0))
(* integer passed_mfactor = "m"; *)
 M1 (y, net1, vss, vss);
ne #(.w(4.2e-07), .l(2.1e-07), .as(2.016e-13), .ad(2.016e-13), .ps(1.8e-06), .pd(1.8e-06), .nrs(0.642857), .nrd(0.642857), .m((1)*(1)), .par1((1)*(1)), .xf_subext(0))
(* integer passed_mfactor = "m"; *)
 MN1 (net1, a, net23, vss);
ne #(.w(4.2e-07), .l(2.1e-07), .as(2.016e-13), .ad(2.016e-13), .ps(1.8e-06), .pd(1.8e-06), .nrs(0.642857), .nrd(0.642857), .m((1)*(1)), .par1((1)*(1)), .xf_subext(0))
(* integer passed_mfactor = "m"; *)
 MN2 (net23, b, vss, vss);
pe #(.w(1.41e-06), .l(2.1e-07), .as(6.768e-13), .ad(6.768e-13), .ps(3.78e-06), .pd(3.78e-06), .nrs(0.191489), .nrd(0.191489), .m((1)*(1)), .par1((1)*(1)))
(* integer passed_mfactor = "m"; *)
 M0 (y, net1, vdd, vdd);
pe #(.w(7.2e-07), .l(2.1e-07), .as(3.456e-13), .ad(3.456e-13), .ps(2.4e-06), .pd(2.4e-06), .nrs(0.375), .nrd(0.375), .m((1)*(1)), .par1((1)*(1)))
(* integer passed_mfactor = "m"; *)
 MP1 (net1, a, vdd, vdd);
pe #(.w(7.2e-07), .l(2.1e-07), .as(3.456e-13), .ad(3.456e-13), .ps(2.4e-06), .pd(2.4e-06), .nrs(0.375), .nrd(0.375), .m((1)*(1)), .par1((1)*(1)))
(* integer passed_mfactor = "m"; *)
 MP2 (net1, b, vdd, vdd);

endmodule
// Library - cell_lib_std, Cell - DLY4_X1, View - schematic
// LAST TIME SAVED: Sep 15 14:44:32 2021
// NETLIST TIME: Sep 11 09:37:24 2025

`worklib cell_lib_std
`view schematic

`timescale 1ns / 1ps
(* cds_ams_schematic *)

module DLY4_X1 (y, a, vdd, vss);
output  y;
input  a, vdd, vss;
pe #(.w(8.1e-07), .l(1.8e-07), .as(3.888e-13), .ad(3.888e-13), .ps(2.58e-06), .pd(2.58e-06), .nrs(0.333333), .nrd(0.333333), .m((1)*(1)), .par1((1)*(1)))
(* integer passed_mfactor = "m"; *)
 M10 (net3, a, vdd, vdd);
pe #(.w(1.41e-06), .l(1.8e-07), .as(6.768e-13), .ad(6.768e-13), .ps(3.78e-06), .pd(3.78e-06), .nrs(0.191489), .nrd(0.191489), .m((1)*(1)), .par1((1)*(1)))
(* integer passed_mfactor = "m"; *)
 M7 (y, net8, vdd, vdd);
pe #(.w(4.2e-07), .l(1.07e-06), .as(2.016e-13), .ad(2.016e-13), .ps(1.8e-06), .pd(1.8e-06), .nrs(0.642857), .nrd(0.642857), .m((1)*(1)), .par1((1)*(1)))
(* integer passed_mfactor = "m"; *)
 M3 (net8, net5, net7, vdd);
pe #(.w(4.2e-07), .l(1.07e-06), .as(2.016e-13), .ad(2.016e-13), .ps(1.8e-06), .pd(1.8e-06), .nrs(0.642857), .nrd(0.642857), .m((1)*(1)), .par1((1)*(1)))
(* integer passed_mfactor = "m"; *)
 M2 (net7, net5, vdd, vdd);
pe #(.w(4.2e-07), .l(6e-07), .as(2.016e-13), .ad(2.016e-13), .ps(1.8e-06), .pd(1.8e-06), .nrs(0.642857), .nrd(0.642857), .m((1)*(1)), .par1((1)*(1)))
(* integer passed_mfactor = "m"; *)
 M1 (net5, net3, net1, vdd);
pe #(.w(4.2e-07), .l(6e-07), .as(2.016e-13), .ad(2.016e-13), .ps(1.8e-06), .pd(1.8e-06), .nrs(0.642857), .nrd(0.642857), .m((1)*(1)), .par1((1)*(1)))
(* integer passed_mfactor = "m"; *)
 M0 (net1, net3, vdd, vdd);
ne #(.w(4.2e-07), .l(1.8e-07), .as(2.016e-13), .ad(2.016e-13), .ps(1.8e-06), .pd(1.8e-06), .nrs(0.642857), .nrd(0.642857), .m((1)*(1)), .par1((1)*(1)), .xf_subext(0))
(* integer passed_mfactor = "m"; *)
 M11 (net3, a, vss, vss);
ne #(.w(8.9e-07), .l(1.8e-07), .as(4.272e-13), .ad(4.272e-13), .ps(2.74e-06), .pd(2.74e-06), .nrs(0.303371), .nrd(0.303371), .m((1)*(1)), .par1((1)*(1)), .xf_subext(0))
(* integer passed_mfactor = "m"; *)
 M9 (y, net8, vss, vss);
ne #(.w(4.2e-07), .l(7e-07), .as(2.016e-13), .ad(2.016e-13), .ps(1.8e-06), .pd(1.8e-06), .nrs(0.642857), .nrd(0.642857), .m((1)*(1)), .par1((1)*(1)), .xf_subext(0))
(* integer passed_mfactor = "m"; *)
 M8 (net9, net5, vss, vss);
ne #(.w(4.2e-07), .l(7e-07), .as(2.016e-13), .ad(2.016e-13), .ps(1.8e-06), .pd(1.8e-06), .nrs(0.642857), .nrd(0.642857), .m((1)*(1)), .par1((1)*(1)), .xf_subext(0))
(* integer passed_mfactor = "m"; *)
 M6 (net8, net5, net9, vss);
ne #(.w(4.2e-07), .l(8.9e-07), .as(2.016e-13), .ad(2.016e-13), .ps(1.8e-06), .pd(1.8e-06), .nrs(0.642857), .nrd(0.642857), .m((1)*(1)), .par1((1)*(1)), .xf_subext(0))
(* integer passed_mfactor = "m"; *)
 M5 (net6, net3, vss, vss);
ne #(.w(4.2e-07), .l(8.9e-07), .as(2.016e-13), .ad(2.016e-13), .ps(1.8e-06), .pd(1.8e-06), .nrs(0.642857), .nrd(0.642857), .m((1)*(1)), .par1((1)*(1)), .xf_subext(0))
(* integer passed_mfactor = "m"; *)
 M4 (net5, net3, net6, vss);

endmodule
// Library - cell_lib_std, Cell - MUX2_X1, View - schematic
// LAST TIME SAVED: Apr 11 16:40:18 2022
// NETLIST TIME: Sep 11 09:37:24 2025

`worklib cell_lib_std
`view schematic

`timescale 1ns / 1ps
(* cds_ams_schematic *)

module MUX2_X1 (y, a, b, s, vdd, vss);
output  y;
input  a, b, s, vdd, vss;
ne #(.w(8.8e-07), .l(2.1e-07), .as(4.224e-13), .ad(4.224e-13), .ps(2.72e-06), .pd(2.72e-06), .nrs(0.306818), .nrd(0.306818), .m((1)*(1)), .par1((1)*(1)), .xf_subext(0))
(* integer passed_mfactor = "m"; *)
 M4 (y, net25, vss, vss);
ne #(.w(5.9e-07), .l(2.1e-07), .as(2.832e-13), .ad(2.832e-13), .ps(2.14e-06), .pd(2.14e-06), .nrs(0.457627), .nrd(0.457627), .m((1)*(1)), .par1((1)*(1)), .xf_subext(0))
(* integer passed_mfactor = "m"; *)
 M7 (net25, s, net29, vss);
ne #(.w(5.9e-07), .l(2.1e-07), .as(2.832e-13), .ad(2.832e-13), .ps(2.14e-06), .pd(2.14e-06), .nrs(0.457627), .nrd(0.457627), .m((1)*(1)), .par1((1)*(1)), .xf_subext(0))
(* integer passed_mfactor = "m"; *)
 M6 (net29, b, vss, vss);
ne #(.w(4.2e-07), .l(2.1e-07), .as(2.016e-13), .ad(2.016e-13), .ps(1.8e-06), .pd(1.8e-06), .nrs(0.642857), .nrd(0.642857), .m((1)*(1)), .par1((1)*(1)), .xf_subext(0))
(* integer passed_mfactor = "m"; *)
 M11 (net26, s, vss, vss);
ne #(.w(5.9e-07), .l(2.1e-07), .as(2.832e-13), .ad(2.832e-13), .ps(2.14e-06), .pd(2.14e-06), .nrs(0.457627), .nrd(0.457627), .m((1)*(1)), .par1((1)*(1)), .xf_subext(0))
(* integer passed_mfactor = "m"; *)
 MN2 (net25, net26, net27, vss);
ne #(.w(5.9e-07), .l(2.1e-07), .as(2.832e-13), .ad(2.832e-13), .ps(2.14e-06), .pd(2.14e-06), .nrs(0.457627), .nrd(0.457627), .m((1)*(1)), .par1((1)*(1)), .xf_subext(0))
(* integer passed_mfactor = "m"; *)
 MN1 (net27, a, vss, vss);
pe #(.w(1.41e-06), .l(2.1e-07), .as(6.768e-13), .ad(6.768e-13), .ps(3.78e-06), .pd(3.78e-06), .nrs(0.191489), .nrd(0.191489), .m((1)*(1)), .par1((1)*(1)))
(* integer passed_mfactor = "m"; *)
 M5 (y, net25, vdd, vdd);
pe #(.w(8e-07), .l(2.1e-07), .as(3.84e-13), .ad(3.84e-13), .ps(2.56e-06), .pd(2.56e-06), .nrs(0.3375), .nrd(0.3375), .m((1)*(1)), .par1((1)*(1)))
(* integer passed_mfactor = "m"; *)
 M9 (net30, b, vdd, vdd);
pe #(.w(8e-07), .l(2.1e-07), .as(3.84e-13), .ad(3.84e-13), .ps(2.56e-06), .pd(2.56e-06), .nrs(0.3375), .nrd(0.3375), .m((1)*(1)), .par1((1)*(1)))
(* integer passed_mfactor = "m"; *)
 M8 (net25, net26, net30, vdd);
pe #(.w(6.3e-07), .l(2.1e-07), .as(3.024e-13), .ad(3.024e-13), .ps(2.22e-06), .pd(2.22e-06), .nrs(0.428571), .nrd(0.428571), .m((1)*(1)), .par1((1)*(1)))
(* integer passed_mfactor = "m"; *)
 M10 (net26, s, vdd, vdd);
pe #(.w(8e-07), .l(2.1e-07), .as(3.84e-13), .ad(3.84e-13), .ps(2.56e-06), .pd(2.56e-06), .nrs(0.3375), .nrd(0.3375), .m((1)*(1)), .par1((1)*(1)))
(* integer passed_mfactor = "m"; *)
 MP1 (net28, a, vdd, vdd);
pe #(.w(8e-07), .l(2.1e-07), .as(3.84e-13), .ad(3.84e-13), .ps(2.56e-06), .pd(2.56e-06), .nrs(0.3375), .nrd(0.3375), .m((1)*(1)), .par1((1)*(1)))
(* integer passed_mfactor = "m"; *)
 MP2 (net25, s, net28, vdd);

endmodule
// Library - cell_lib_std, Cell - BUF_X1, View - schematic
// LAST TIME SAVED: Feb 24 12:18:38 2021
// NETLIST TIME: Sep 11 09:37:24 2025

`worklib cell_lib_std
`view schematic

`timescale 1ns / 1ps
(* cds_ams_schematic *)

module BUF_X1 (y, a, vdd, vss);
output  y;
input  a, vdd, vss;
ne #(.w(4.2e-07), .l(2.1e-07), .as(2.016e-13), .ad(2.016e-13), .ps(1.8e-06), .pd(1.8e-06), .nrs(0.642857), .nrd(0.642857), .m((1)*(1)), .par1((1)*(1)), .xf_subext(0))
(* integer passed_mfactor = "m"; *)
 M0 (net1, a, vss, vss);
ne #(.w(5.8e-07), .l(2.1e-07), .as(2.784e-13), .ad(2.784e-13), .ps(2.12e-06), .pd(2.12e-06), .nrs(0.465517), .nrd(0.465517), .m((1)*(1)), .par1((1)*(1)), .xf_subext(0))
(* integer passed_mfactor = "m"; *)
 ne (y, net1, vss, vss);
pe #(.w(7.2e-07), .l(2.1e-07), .as(3.456e-13), .ad(3.456e-13), .ps(2.4e-06), .pd(2.4e-06), .nrs(0.375), .nrd(0.375), .m((1)*(1)), .par1((1)*(1)))
(* integer passed_mfactor = "m"; *)
 M1 (net1, a, vdd, vdd);
pe #(.w(1.41e-06), .l(2.1e-07), .as(6.768e-13), .ad(6.768e-13), .ps(3.78e-06), .pd(3.78e-06), .nrs(0.191489), .nrd(0.191489), .m((1)*(1)), .par1((1)*(1)))
(* integer passed_mfactor = "m"; *)
 pe (y, net1, vdd, vdd);

endmodule
// Library - cell_lib_async, Cell - KEEPB_X1, View - schematic
// LAST TIME SAVED: Mar 15 00:21:51 2021
// NETLIST TIME: Sep 11 09:37:24 2025

`worklib cell_lib_async
`view schematic

`timescale 1ns / 1ps
(* cds_ams_schematic *)

module KEEPB_X1 (y, a, vdd, vss);
output  y;
input  vdd, vss;
inout  a;
ne #(.w(2.9e-07), .l(6.3e-07), .as(1.392e-13), .ad(1.392e-13), .ps(1.54e-06), .pd(1.54e-06), .nrs(0.931034), .nrd(0.931034), .m((1)*(1)), .par1((1)*(1)), .xf_subext(0))
(* integer passed_mfactor = "m"; *)
 M5 (net5, vdd, vss, vss);
ne #(.w(5.8e-07), .l(2.1e-07), .as(2.784e-13), .ad(2.784e-13), .ps(2.12e-06), .pd(2.12e-06), .nrs(0.465517), .nrd(0.465517), .m((1)*(1)), .par1((1)*(1)), .xf_subext(0))
(* integer passed_mfactor = "m"; *)
 M1 (y, a, vss, vss);
ne #(.w(2.9e-07), .l(2.1e-07), .as(1.392e-13), .ad(1.392e-13), .ps(1.54e-06), .pd(1.54e-06), .nrs(0.931034), .nrd(0.931034), .m((1)*(1)), .par1((1)*(1)), .xf_subext(0))
(* integer passed_mfactor = "m"; *)
 M2 (a, y, net5, vss);
pe #(.w(4.5e-07), .l(6.3e-07), .as(2.16e-13), .ad(2.16e-13), .ps(1.86e-06), .pd(1.86e-06), .nrs(0.6), .nrd(0.6), .m((1)*(1)), .par1((1)*(1)))
(* integer passed_mfactor = "m"; *)
 M4 (net6, vss, vdd, vdd);
pe #(.w(4.5e-07), .l(2.1e-07), .as(2.16e-13), .ad(2.16e-13), .ps(1.86e-06), .pd(1.86e-06), .nrs(0.6), .nrd(0.6), .m((1)*(1)), .par1((1)*(1)))
(* integer passed_mfactor = "m"; *)
 M3 (a, y, net6, vdd);
pe #(.w(9e-07), .l(2.1e-07), .as(4.32e-13), .ad(4.32e-13), .ps(2.76e-06), .pd(2.76e-06), .nrs(0.3), .nrd(0.3), .m((1)*(1)), .par1((1)*(1)))
(* integer passed_mfactor = "m"; *)
 M0 (y, a, vdd, vdd);

endmodule
// Library - cell_lib_async, Cell - A_2C_RB_X1, View - schematic
// LAST TIME SAVED: Feb 25 12:57:58 2025
// NETLIST TIME: Sep 11 09:37:24 2025

`worklib cell_lib_async
`view schematic

`timescale 1ns / 1ps
(* cds_ams_schematic *)

module A_2C_RB_X1 (y, c1, c2, pr_B, sr_B, vdd, vss);
output  y;
input  c1, c2, pr_B, sr_B, vdd, vss;
wire a;
KEEPB_X1 I_keepb_0 (.vdd( vdd ), .y( y ), .vss( vss ), .a( a ));
pe #(.w(9e-07), .l(2.1e-07), .as(4.32e-13), .ad(4.32e-13), .ps(2.76e-06), .pd(2.76e-06), .nrs(0.3), .nrd(0.3), .m((1)*(1)), .par1((1)*(1)))
(* integer passed_mfactor = "m"; *)
 M5 (a, pr_B, vdd, vdd);
pe #(.w(9e-07), .l(2.1e-07), .as(4.32e-13), .ad(2.43e-13), .ps(2.76e-06), .pd(1.44e-06), .nrs(0.3), .nrd(0.3), .m((1)*(2)), .par1((1)*(2)))
(* integer passed_mfactor = "m"; *)
 M2 (a, c2, net1, vdd);
pe #(.w(9e-07), .l(2.1e-07), .as(4.32e-13), .ad(2.43e-13), .ps(2.76e-06), .pd(1.44e-06), .nrs(0.3), .nrd(0.3), .m((1)*(2)), .par1((1)*(2)))
(* integer passed_mfactor = "m"; *)
 M4 (net1, c1, vdd, vdd);
ne #(.w(5.8e-07), .l(2.1e-07), .as(1.972e-13), .ad(1.972e-13), .ps(1.45333e-06), .pd(1.45333e-06), .nrs(0.465517), .nrd(0.465517), .m((1)*(3)), .par1((1)*(3)), .xf_subext(0))
(* integer passed_mfactor = "m"; *)
 M7 (net3, sr_B, vss, vss);
ne #(.w(5.8e-07), .l(2.1e-07), .as(1.972e-13), .ad(1.972e-13), .ps(1.45333e-06), .pd(1.45333e-06), .nrs(0.465517), .nrd(0.465517), .m((1)*(3)), .par1((1)*(3)), .xf_subext(0))
(* integer passed_mfactor = "m"; *)
 M1 (net2, c1, net3, vss);
ne #(.w(5.8e-07), .l(2.1e-07), .as(1.972e-13), .ad(1.972e-13), .ps(1.45333e-06), .pd(1.45333e-06), .nrs(0.465517), .nrd(0.465517), .m((1)*(3)), .par1((1)*(3)), .xf_subext(0))
(* integer passed_mfactor = "m"; *)
 M3 (a, c2, net2, vss);

endmodule
// Library - cell_lib_async, Cell - KEEPB_X4, View - schematic
// LAST TIME SAVED: May  5 12:36:02 2022
// NETLIST TIME: Sep 11 09:37:24 2025

`worklib cell_lib_async
`view schematic

`timescale 1ns / 1ps
(* cds_ams_schematic *)

module KEEPB_X4 (y, a, vdd, vss);
output  y;
input  vdd, vss;
inout  a;
ne #(.w(2.9e-07), .l(6.3e-07), .as(1.392e-13), .ad(1.392e-13), .ps(1.54e-06), .pd(1.54e-06), .nrs(0.931034), .nrd(0.931034), .m((1)*(1)), .par1((1)*(1)), .xf_subext(0))
(* integer passed_mfactor = "m"; *)
 M5 (net5, vdd, vss, vss);
ne #(.w(7.75e-07), .l(2.1e-07), .as(2.635e-13), .ad(2.635e-13), .ps(1.71333e-06), .pd(1.71333e-06), .nrs(0.348387), .nrd(0.348387), .m((1)*(3)), .par1((1)*(3)), .xf_subext(0))
(* integer passed_mfactor = "m"; *)
 M1 (y, a, vss, vss);
ne #(.w(2.9e-07), .l(2.1e-07), .as(1.392e-13), .ad(1.392e-13), .ps(1.54e-06), .pd(1.54e-06), .nrs(0.931034), .nrd(0.931034), .m((1)*(1)), .par1((1)*(1)), .xf_subext(0))
(* integer passed_mfactor = "m"; *)
 M2 (a, y, net5, vss);
pe #(.w(4.5e-07), .l(6.3e-07), .as(2.16e-13), .ad(2.16e-13), .ps(1.86e-06), .pd(1.86e-06), .nrs(0.6), .nrd(0.6), .m((1)*(1)), .par1((1)*(1)))
(* integer passed_mfactor = "m"; *)
 M4 (net6, vss, vdd, vdd);
pe #(.w(4.5e-07), .l(2.1e-07), .as(2.16e-13), .ad(2.16e-13), .ps(1.86e-06), .pd(1.86e-06), .nrs(0.6), .nrd(0.6), .m((1)*(1)), .par1((1)*(1)))
(* integer passed_mfactor = "m"; *)
 M3 (a, y, net6, vdd);
pe #(.w(1.2e-06), .l(2.1e-07), .as(4.08e-13), .ad(4.08e-13), .ps(2.28e-06), .pd(2.28e-06), .nrs(0.225), .nrd(0.225), .m((1)*(3)), .par1((1)*(3)))
(* integer passed_mfactor = "m"; *)
 M0 (y, a, vdd, vdd);

endmodule
// Library - cell_lib_async, Cell - A_3C_RB_X4, View - schematic
// LAST TIME SAVED: Feb 25 12:57:59 2025
// NETLIST TIME: Sep 11 09:37:24 2025

`worklib cell_lib_async
`view schematic

`timescale 1ns / 1ps
(* cds_ams_schematic *)

module A_3C_RB_X4 (y, c1, c2, c3, pr_B, sr_B, vdd, vss);
output  y;
input  c1, c2, c3, pr_B, sr_B, vdd, vss;
wire net15;
KEEPB_X4 I_keepb_0 (.vdd( vdd ), .y( y ), .vss( vss ), .a( net15 ));
ne #(.w(7.75e-07), .l(2.1e-07), .as(2.635e-13), .ad(2.635e-13), .ps(1.71333e-06), .pd(1.71333e-06), .nrs(0.348387), .nrd(0.348387), .m((1)*(3)), .par1((1)*(3)), .xf_subext(0))
(* integer passed_mfactor = "m"; *)
 M0 (net15, c1, net19, vss);
ne #(.w(7.75e-07), .l(2.1e-07), .as(2.635e-13), .ad(2.635e-13), .ps(1.71333e-06), .pd(1.71333e-06), .nrs(0.348387), .nrd(0.348387), .m((1)*(3)), .par1((1)*(3)), .xf_subext(0))
(* integer passed_mfactor = "m"; *)
 M1 (net19, c2, net17, vss);
ne #(.w(7.75e-07), .l(2.1e-07), .as(2.635e-13), .ad(2.635e-13), .ps(1.71333e-06), .pd(1.71333e-06), .nrs(0.348387), .nrd(0.348387), .m((1)*(3)), .par1((1)*(3)), .xf_subext(0))
(* integer passed_mfactor = "m"; *)
 M2 (net17, c3, net8, vss);
ne #(.w(7.75e-07), .l(2.1e-07), .as(2.635e-13), .ad(2.635e-13), .ps(1.71333e-06), .pd(1.71333e-06), .nrs(0.348387), .nrd(0.348387), .m((1)*(3)), .par1((1)*(3)), .xf_subext(0))
(* integer passed_mfactor = "m"; *)
 M6 (net8, sr_B, vss, vss);
pe #(.w(9.9e-07), .l(2.1e-07), .as(3.366e-13), .ad(3.366e-13), .ps(2e-06), .pd(2e-06), .nrs(0.272727), .nrd(0.272727), .m((1)*(3)), .par1((1)*(3)))
(* integer passed_mfactor = "m"; *)
 M3 (net15, c1, net18, vdd);
pe #(.w(9.9e-07), .l(2.1e-07), .as(3.366e-13), .ad(3.366e-13), .ps(2e-06), .pd(2e-06), .nrs(0.272727), .nrd(0.272727), .m((1)*(3)), .par1((1)*(3)))
(* integer passed_mfactor = "m"; *)
 M4 (net18, c2, net16, vdd);
pe #(.w(9.9e-07), .l(2.1e-07), .as(3.366e-13), .ad(3.366e-13), .ps(2e-06), .pd(2e-06), .nrs(0.272727), .nrd(0.272727), .m((1)*(3)), .par1((1)*(3)))
(* integer passed_mfactor = "m"; *)
 M5 (net16, c3, vdd, vdd);
pe #(.w(9.9e-07), .l(2.1e-07), .as(4.752e-13), .ad(4.752e-13), .ps(2.94e-06), .pd(2.94e-06), .nrs(0.272727), .nrd(0.272727), .m((1)*(1)), .par1((1)*(1)))
(* integer passed_mfactor = "m"; *)
 M7 (net15, pr_B, vdd, vdd);

endmodule
// Library - cell_lib_async, Cell - A_2C1N_RB_X4, View - schematic
// LAST TIME SAVED: Feb 25 12:58:05 2025
// NETLIST TIME: Sep 11 09:37:24 2025

`worklib cell_lib_async
`view schematic

`timescale 1ns / 1ps
(* cds_ams_schematic *)

module A_2C1N_RB_X4 (y, c1, c2, n1, pr_B, sr_B, vdd, vss);
output  y;
input  c1, c2, n1, pr_B, sr_B, vdd, vss;
wire net1;
KEEPB_X4 I_keep_0 (.y( y ), .vdd( vdd ), .vss( vss ), .a( net1 ));
ne #(.w(7.75e-07), .l(2.1e-07), .as(2.635e-13), .ad(2.635e-13), .ps(1.71333e-06), .pd(1.71333e-06), .nrs(0.348387), .nrd(0.348387), .m((1)*(3)), .par1((1)*(3)), .xf_subext(0))
(* integer passed_mfactor = "m"; *)
 M3 (net1, c2, net3, vss);
ne #(.w(7.75e-07), .l(2.1e-07), .as(2.635e-13), .ad(2.635e-13), .ps(1.71333e-06), .pd(1.71333e-06), .nrs(0.348387), .nrd(0.348387), .m((1)*(3)), .par1((1)*(3)), .xf_subext(0))
(* integer passed_mfactor = "m"; *)
 M11 (net3, c1, net4, vss);
ne #(.w(7.75e-07), .l(2.1e-07), .as(2.635e-13), .ad(2.635e-13), .ps(1.71333e-06), .pd(1.71333e-06), .nrs(0.348387), .nrd(0.348387), .m((1)*(3)), .par1((1)*(3)), .xf_subext(0))
(* integer passed_mfactor = "m"; *)
 M12 (net4, n1, net8, vss);
ne #(.w(7.75e-07), .l(2.1e-07), .as(2.635e-13), .ad(2.635e-13), .ps(1.71333e-06), .pd(1.71333e-06), .nrs(0.348387), .nrd(0.348387), .m((1)*(3)), .par1((1)*(3)), .xf_subext(0))
(* integer passed_mfactor = "m"; *)
 M13 (net8, sr_B, vss, vss);
pe #(.w(4.5e-07), .l(2.1e-07), .as(2.16e-13), .ad(1.215e-13), .ps(1.86e-06), .pd(9.9e-07), .nrs(0.6), .nrd(0.6), .m((1)*(2)), .par1((1)*(2)))
(* integer passed_mfactor = "m"; *)
 M4 (net1, pr_B, vdd, vdd);
pe #(.w(6e-07), .l(2.1e-07), .as(2.04e-13), .ad(2.04e-13), .ps(1.48e-06), .pd(1.48e-06), .nrs(0.45), .nrd(0.45), .m((1)*(3)), .par1((1)*(3)))
(* integer passed_mfactor = "m"; *)
 M5 (net1, c1, net2, vdd);
pe #(.w(6e-07), .l(2.1e-07), .as(2.04e-13), .ad(2.04e-13), .ps(1.48e-06), .pd(1.48e-06), .nrs(0.45), .nrd(0.45), .m((1)*(3)), .par1((1)*(3)))
(* integer passed_mfactor = "m"; *)
 M14 (net2, c2, vdd, vdd);

endmodule
// Library - cell_lib_async, Cell - KEEP, View - schematic
// LAST TIME SAVED: Apr 19 14:33:06 2022
// NETLIST TIME: Sep 11 09:37:24 2025

`worklib cell_lib_async
`view schematic

`timescale 1ns / 1ps
(* cds_ams_schematic *)

module KEEP (y, vdd, vss);
input  vdd, vss;
inout  y;
ne #(.w(2.9e-07), .l(6.3e-07), .as(1.392e-13), .ad(1.392e-13), .ps(1.54e-06), .pd(1.54e-06), .nrs(0.931034), .nrd(0.931034), .m((1)*(1)), .par1((1)*(1)), .xf_subext(0))
(* integer passed_mfactor = "m"; *)
 M5 (net5, vdd, vss, vss);
ne #(.w(2.9e-07), .l(2.1e-07), .as(1.392e-13), .ad(1.392e-13), .ps(1.54e-06), .pd(1.54e-06), .nrs(0.931034), .nrd(0.931034), .m((1)*(1)), .par1((1)*(1)), .xf_subext(0))
(* integer passed_mfactor = "m"; *)
 M1 (net1, y, vss, vss);
ne #(.w(2.9e-07), .l(2.1e-07), .as(1.392e-13), .ad(1.392e-13), .ps(1.54e-06), .pd(1.54e-06), .nrs(0.931034), .nrd(0.931034), .m((1)*(1)), .par1((1)*(1)), .xf_subext(0))
(* integer passed_mfactor = "m"; *)
 M2 (y, net1, net5, vss);
pe #(.w(4.5e-07), .l(6.3e-07), .as(2.16e-13), .ad(2.16e-13), .ps(1.86e-06), .pd(1.86e-06), .nrs(0.6), .nrd(0.6), .m((1)*(1)), .par1((1)*(1)))
(* integer passed_mfactor = "m"; *)
 M4 (net6, vss, vdd, vdd);
pe #(.w(4.5e-07), .l(2.1e-07), .as(2.16e-13), .ad(2.16e-13), .ps(1.86e-06), .pd(1.86e-06), .nrs(0.6), .nrd(0.6), .m((1)*(1)), .par1((1)*(1)))
(* integer passed_mfactor = "m"; *)
 M3 (y, net1, net6, vdd);
pe #(.w(4.5e-07), .l(2.1e-07), .as(2.16e-13), .ad(2.16e-13), .ps(1.86e-06), .pd(1.86e-06), .nrs(0.6), .nrd(0.6), .m((1)*(1)), .par1((1)*(1)))
(* integer passed_mfactor = "m"; *)
 M0 (net1, y, vdd, vdd);

endmodule
// Library - cell_lib_async, Cell - A_1C1P_X1, View - schematic
// LAST TIME SAVED: Feb 25 12:58:04 2025
// NETLIST TIME: Sep 11 09:37:24 2025

`worklib cell_lib_async
`view schematic

`timescale 1ns / 1ps
(* cds_ams_schematic *)

module A_1C1P_X1 (y, c1, p1, vdd, vss);
output  y;
input  c1, p1, vdd, vss;
KEEP I_keep_0 (.y( y ), .vdd( vdd ), .vss( vss ));
ne #(.w(5.8e-07), .l(2.1e-07), .as(2.784e-13), .ad(2.784e-13), .ps(2.12e-06), .pd(2.12e-06), .nrs(0.465517), .nrd(0.465517), .m((1)*(1)), .par1((1)*(1)), .xf_subext(0))
(* integer passed_mfactor = "m"; *)
 M3 (y, c1, vss, vss);
pe #(.w(1.8e-06), .l(2.1e-07), .as(8.64e-13), .ad(8.64e-13), .ps(4.56e-06), .pd(4.56e-06), .nrs(0.15), .nrd(0.15), .m((1)*(1)), .par1((1)*(1)))
(* integer passed_mfactor = "m"; *)
 M4 (net1, p1, vdd, vdd);
pe #(.w(9e-07), .l(2.1e-07), .as(4.32e-13), .ad(2.43e-13), .ps(2.76e-06), .pd(1.44e-06), .nrs(0.3), .nrd(0.3), .m((1)*(2)), .par1((1)*(2)))
(* integer passed_mfactor = "m"; *)
 M0 (y, c1, net1, vdd);

endmodule
// Library - cell_lib_async, Cell - ARBITER, View - schematic
// LAST TIME SAVED: Apr 11 13:28:16 2022
// NETLIST TIME: Sep 11 09:37:24 2025

`worklib cell_lib_async
`view schematic

`timescale 1ns / 1ps
(* cds_ams_schematic *)

module ARBITER (y1, y2, a, b, c, d, vdd, vss);
output  y1, y2;
input  a, b, c, d, vdd, vss;
wire var1;
wire var2;
NAND2_X1 I_nand2_1 (.y( var2 ), .vss( vss ), .vdd( vdd ), .a( var1 ), .b( b ));
NAND2_X1 I_nand2_0 (.y( var1 ), .vss( vss ), .vdd( vdd ), .a( var2 ), .b( a ));
ne #(.w(9e-07), .l(2.1e-07), .as(4.32e-13), .ad(4.32e-13), .ps(2.76e-06), .pd(2.76e-06), .nrs(0.3), .nrd(0.3), .m((1)*(1)), .par1((1)*(1)), .xf_subext(0))
(* integer passed_mfactor = "m"; *)
 M7 (y2, var2, vss, vss);
ne #(.w(9e-07), .l(2.1e-07), .as(4.32e-13), .ad(4.32e-13), .ps(2.76e-06), .pd(2.76e-06), .nrs(0.3), .nrd(0.3), .m((1)*(1)), .par1((1)*(1)), .xf_subext(0))
(* integer passed_mfactor = "m"; *)
 M6 (y2, d, vss, vss);
ne #(.w(9e-07), .l(2.1e-07), .as(4.32e-13), .ad(4.32e-13), .ps(2.76e-06), .pd(2.76e-06), .nrs(0.3), .nrd(0.3), .m((1)*(1)), .par1((1)*(1)), .xf_subext(0))
(* integer passed_mfactor = "m"; *)
 M5 (y1, c, vss, vss);
ne #(.w(9e-07), .l(2.1e-07), .as(4.32e-13), .ad(4.32e-13), .ps(2.76e-06), .pd(2.76e-06), .nrs(0.3), .nrd(0.3), .m((1)*(1)), .par1((1)*(1)), .xf_subext(0))
(* integer passed_mfactor = "m"; *)
 M4 (y1, var1, vss, vss);
pe #(.w(1.41e-06), .l(2.1e-07), .as(6.768e-13), .ad(6.768e-13), .ps(3.78e-06), .pd(3.78e-06), .nrs(0.191489), .nrd(0.191489), .m((1)*(1)), .par1((1)*(1)))
(* integer passed_mfactor = "m"; *)
 M1 (y2, var2, net13, vdd);
pe #(.w(1.41e-06), .l(2.1e-07), .as(6.768e-13), .ad(6.768e-13), .ps(3.78e-06), .pd(3.78e-06), .nrs(0.191489), .nrd(0.191489), .m((1)*(1)), .par1((1)*(1)))
(* integer passed_mfactor = "m"; *)
 M0 (net13, d, var1, vdd);
pe #(.w(1.41e-06), .l(2.1e-07), .as(6.768e-13), .ad(6.768e-13), .ps(3.78e-06), .pd(3.78e-06), .nrs(0.191489), .nrd(0.191489), .m((1)*(1)), .par1((1)*(1)))
(* integer passed_mfactor = "m"; *)
 M2 (net7, c, var2, vdd);
pe #(.w(1.41e-06), .l(2.1e-07), .as(6.768e-13), .ad(6.768e-13), .ps(3.78e-06), .pd(3.78e-06), .nrs(0.191489), .nrd(0.191489), .m((1)*(1)), .par1((1)*(1)))
(* integer passed_mfactor = "m"; *)
 M3 (y1, var1, net7, vdd);

endmodule
// Library - cell_lib_async, Cell - A_2C_B_X1, View - schematic
// LAST TIME SAVED: May 17 11:27:50 2021
// NETLIST TIME: Sep 11 09:37:24 2025

`worklib cell_lib_async
`view schematic

`timescale 1ns / 1ps
(* cds_ams_schematic *)

module A_2C_B_X1 (y, c1, c2, vdd, vss);
output  y;
input  c1, c2, vdd, vss;
wire net1;
INV_X1 I_inv_0 (.vdd( vdd ), .y( y ), .vss( vss ), .a( net1 ));
pe #(.w(9e-07), .l(2.1e-07), .as(4.32e-13), .ad(4.32e-13), .ps(2.76e-06), .pd(2.76e-06), .nrs(0.3), .nrd(0.3), .m((1)*(1)), .par1((1)*(1)))
(* integer passed_mfactor = "m"; *)
 M4 (net3, y, net8, vdd);
pe #(.w(9e-07), .l(2.1e-07), .as(4.32e-13), .ad(4.32e-13), .ps(2.76e-06), .pd(2.76e-06), .nrs(0.3), .nrd(0.3), .m((1)*(1)), .par1((1)*(1)))
(* integer passed_mfactor = "m"; *)
 M3 (net1, c2, net8, vdd);
pe #(.w(9e-07), .l(2.1e-07), .as(4.32e-13), .ad(4.32e-13), .ps(2.76e-06), .pd(2.76e-06), .nrs(0.3), .nrd(0.3), .m((1)*(1)), .par1((1)*(1)))
(* integer passed_mfactor = "m"; *)
 M2 (net8, c1, vdd, vdd);
pe #(.w(9e-07), .l(2.1e-07), .as(4.32e-13), .ad(4.32e-13), .ps(2.76e-06), .pd(2.76e-06), .nrs(0.3), .nrd(0.3), .m((1)*(1)), .par1((1)*(1)))
(* integer passed_mfactor = "m"; *)
 M1 (net1, c1, net3, vdd);
pe #(.w(9e-07), .l(2.1e-07), .as(4.32e-13), .ad(4.32e-13), .ps(2.76e-06), .pd(2.76e-06), .nrs(0.3), .nrd(0.3), .m((1)*(1)), .par1((1)*(1)))
(* integer passed_mfactor = "m"; *)
 M0 (net3, c2, vdd, vdd);
ne #(.w(5.8e-07), .l(2.1e-07), .as(2.784e-13), .ad(2.784e-13), .ps(2.12e-06), .pd(2.12e-06), .nrs(0.465517), .nrd(0.465517), .m((1)*(1)), .par1((1)*(1)), .xf_subext(0))
(* integer passed_mfactor = "m"; *)
 M5 (net1, c2, net18, vss);
ne #(.w(5.8e-07), .l(2.1e-07), .as(2.784e-13), .ad(2.784e-13), .ps(2.12e-06), .pd(2.12e-06), .nrs(0.465517), .nrd(0.465517), .m((1)*(1)), .par1((1)*(1)), .xf_subext(0))
(* integer passed_mfactor = "m"; *)
 M10 (net18, y, net9, vss);
ne #(.w(5.8e-07), .l(2.1e-07), .as(2.784e-13), .ad(2.784e-13), .ps(2.12e-06), .pd(2.12e-06), .nrs(0.465517), .nrd(0.465517), .m((1)*(1)), .par1((1)*(1)), .xf_subext(0))
(* integer passed_mfactor = "m"; *)
 M9 (net9, c2, vss, vss);
ne #(.w(5.8e-07), .l(2.1e-07), .as(2.784e-13), .ad(2.784e-13), .ps(2.12e-06), .pd(2.12e-06), .nrs(0.465517), .nrd(0.465517), .m((1)*(1)), .par1((1)*(1)), .xf_subext(0))
(* integer passed_mfactor = "m"; *)
 M7 (net1, c1, net9, vss);
ne #(.w(5.8e-07), .l(2.1e-07), .as(2.784e-13), .ad(2.784e-13), .ps(2.12e-06), .pd(2.12e-06), .nrs(0.465517), .nrd(0.465517), .m((1)*(1)), .par1((1)*(1)), .xf_subext(0))
(* integer passed_mfactor = "m"; *)
 M6 (net18, c1, vss, vss);

endmodule
// Library - enc_test, Cell - paer_5_of_10, View - schematic
// LAST TIME SAVED: Sep 11 09:28:45 2025
// NETLIST TIME: Sep 11 09:37:24 2025

`worklib enc_test
`view schematic

`timescale 1ns / 1ps
(* cds_ams_schematic *)

module paer_5_of_10 ( );
wire [0:4] net3;
wire [9:0] req_p;
wire [9:0] ack_p;
wire [3:0] Iout_d;
wire [0:4] net2;
wire vdd;
wire reset_B;
wire req_ack_out;
sadc__encoder I0 (.Iin_a( ack_p ), .Iout_d( Iout_d ), .Iin_d_d0( req_p ), .Iout_r( req_ack_out ), .Idly_cfg0(cds_globals.\gnd! ), .Iout_a( req_ack_out ), .reset_B( reset_B ), .vdd( vdd ), .vss(cds_globals.\gnd! ));
spike_source I13 (.req_p( req_p ), .req_s( net3 ), .ack_p( ack_p ), .ack_s( net2 ));
vsource #(.dc(1.8), .type("dc")) V0 (vdd, cds_globals.\gnd! );
vsource #(.type("pulse"), .val0(0), .val1(1.8), .period(10), .delay(1e-09), .rise(1e-09), .fall(1e-09), .width(10)) V1 (reset_B, cds_globals.\gnd! );

endmodule
// Library - xp018_cell_lib_std, Cell - NAND2_X1, View - schematic
// LAST TIME SAVED: Feb 22 16:42:48 2021
// NETLIST TIME: Sep 11 09:37:24 2025

`worklib xp018_cell_lib_std
`view schematic

`timescale 1ns / 1ps
(* cds_ams_schematic *)

module NAND2_X1 (y, a, b, vdd, vss);
output  y;
input  a, b, vdd, vss;
ne #(.w(8.9e-07), .l(2.1e-07), .as(4.272e-13), .ad(4.272e-13), .ps(2.74e-06), .pd(2.74e-06), .nrs(0.303371), .nrd(0.303371), .m((1)*(1)), .par1((1)*(1)), .xf_subext(0))
(* integer passed_mfactor = "m"; *)
 MN1 (y, a, net18, vss);
ne #(.w(8.9e-07), .l(2.1e-07), .as(4.272e-13), .ad(4.272e-13), .ps(2.74e-06), .pd(2.74e-06), .nrs(0.303371), .nrd(0.303371), .m((1)*(1)), .par1((1)*(1)), .xf_subext(0))
(* integer passed_mfactor = "m"; *)
 MN2 (net18, b, vss, vss);
pe #(.w(1.01e-06), .l(2.1e-07), .as(4.848e-13), .ad(4.848e-13), .ps(2.98e-06), .pd(2.98e-06), .nrs(0.267327), .nrd(0.267327), .m((1)*(1)), .par1((1)*(1)))
(* integer passed_mfactor = "m"; *)
 MP1 (y, a, vdd, vdd);
pe #(.w(1.01e-06), .l(2.1e-07), .as(4.848e-13), .ad(4.848e-13), .ps(2.98e-06), .pd(2.98e-06), .nrs(0.267327), .nrd(0.267327), .m((1)*(1)), .par1((1)*(1)))
(* integer passed_mfactor = "m"; *)
 MP2 (y, b, vdd, vdd);

endmodule
// Library - xp018_cell_lib_std, Cell - INV_X1, View - schematic
// LAST TIME SAVED: Feb 22 00:11:37 2021
// NETLIST TIME: Sep 11 09:37:24 2025

`worklib xp018_cell_lib_std
`view schematic

`timescale 1ns / 1ps
(* cds_ams_schematic *)

module INV_X1 (y, a, vdd, vss);
output  y;
input  a, vdd, vss;
ne #(.w(5.8e-07), .l(2.1e-07), .as(2.784e-13), .ad(2.784e-13), .ps(2.12e-06), .pd(2.12e-06), .nrs(0.465517), .nrd(0.465517), .m((1)*(1)), .par1((1)*(1)), .xf_subext(0))
(* integer passed_mfactor = "m"; *)
 M1 (y, a, vss, vss);
pe #(.w(1.41e-06), .l(2.1e-07), .as(6.768e-13), .ad(6.768e-13), .ps(3.78e-06), .pd(3.78e-06), .nrs(0.191489), .nrd(0.191489), .m((1)*(1)), .par1((1)*(1)))
(* integer passed_mfactor = "m"; *)
 M0 (y, a, vdd, vdd);

endmodule
`noworklib
`noview
